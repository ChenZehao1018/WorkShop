ADE simulation setup
Run mode: Single Run, Sweeps and Corners
Tests:
  EDATP:LOGIC_1bit_TB:1: EDATP/LOGIC_1bit_TB/schematic, simulator spectre
    Outputs: /A; /B; /CTR<1>; /CTR<0>; /O
Global variables:
  Tp = 2n
  VDD = 1.2
