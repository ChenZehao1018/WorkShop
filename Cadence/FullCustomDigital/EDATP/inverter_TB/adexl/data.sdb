ADE simulation setup
Run mode: Single Run, Sweeps and Corners
Tests:
  EDATP:inverter_TB:1: EDATP/inverter_TB/schematic, simulator spectre
    Outputs: /I; /O
