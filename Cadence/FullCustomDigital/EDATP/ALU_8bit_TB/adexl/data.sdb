ADE simulation setup
Run mode: Single Run, Sweeps and Corners
Tests:
  EDATP:ALU_8bit_TB:1: EDATP/ALU_8bit_TB/schematic_2, simulator spectre
    Outputs: /A<0>; /CTR<0>; /CTR<1>; /S; /O<0>; /B<0>; /vdd; /O<7>; /B_PEX<0>; /O_PEX<7>
Global variables:
  period = 2n
  VDD = 1.2
  Wn = 240n
  Wp = 400n
