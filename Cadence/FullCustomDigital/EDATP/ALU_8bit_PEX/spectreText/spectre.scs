// File: /home/edauser64/edalab2022_fullcust/CDS_VISO/EDATP/ALU_8bit_PEX/spectreText/spectre.scs
// Created: Fri Oct 28 19:02:42 2022
// Program "Calibre xRC"
// Version "v2020.1_17.9"
//
simulator lang=spectre
include "/home/edauser64/edalab2022_fullcust/CDS_VISO/EDATP/ALU_8bit_PEX/spectreText/spectre.scs.pex"
subckt ALU_8bit_PEX (  GND A\<0\> B\<0\> CTR\<1\> CTR\<0\> SEL B\<1\> A\<1\> \
 B\<2\> A\<2\> B\<3\> A\<3\> B\<4\> A\<4\> B\<5\> A\<5\> B\<6\> A\<6\> B\<7\> \
 A\<7\> VDD O\<0\> O\<1\> O\<2\> O\<3\> O\<4\> O\<5\> O\<6\> O\<7\> )
//
// O<7>	O<7>
// O<6>	O<6>
// O<5>	O<5>
// O<4>	O<4>
// O<3>	O<3>
// O<2>	O<2>
// O<1>	O<1>
// O<0>	O<0>
// VDD	VDD
// A<7>	A<7>
// B<7>	B<7>
// A<6>	A<6>
// B<6>	B<6>
// A<5>	A<5>
// B<5>	B<5>
// A<4>	A<4>
// B<4>	B<4>
// A<3>	A<3>
// B<3>	B<3>
// A<2>	A<2>
// B<2>	B<2>
// A<1>	A<1>
// B<1>	B<1>
// SEL	SEL
// CTR<0>	CTR<0>
// CTR<1>	CTR<1>
// B<0>	B<0>
// A<0>	A<0>
// GND	GND
mXI4\/XI18\/MNM0 ( N_XI4\/XI18\/NET248_XI4\/XI18\/MNM0_d \
 N_GND_XI4\/XI18\/MNM0_g N_XI4\/XI18\/NET246_XI4\/XI18\/MNM0_s \
 N_GND_XI4\/XI18\/MNM6_b ) N_12_LLRVT l=6e-08 w=4e-07 ad=4e-14 as=4e-14 \
 pd=6e-07 ps=6e-07 nrd=0 nrs=0 sa=6.8e-07 sb=2.76e-06 sca=0.602605 \
 scb=2.67635e-06 scc=7.14388e-12
mXI4\/XI18\/MNM7 ( N_XI4\/XI18\/NET252_XI4\/XI18\/MNM7_d \
 N_A\<0\>_XI4\/XI18\/MNM7_g N_GND_XI4\/XI18\/MNM7_s N_GND_XI4\/XI18\/MNM6_b ) \
 N_12_LLRVT l=6e-08 w=4e-07 ad=4e-14 as=4e-14 pd=6e-07 ps=6e-07 nrd=0 nrs=0 \
 sa=1.46e-06 sb=1.98e-06 sca=0.602605 scb=2.67635e-06 scc=7.14388e-12
mXI4\/XI18\/MNM8 ( N_XI4\/XI18\/NET252_XI4\/XI18\/MNM8_d \
 N_B\<0\>_XI4\/XI18\/MNM8_g N_GND_XI4\/XI18\/MNM8_s N_GND_XI4\/XI18\/MNM6_b ) \
 N_12_LLRVT l=6e-08 w=4e-07 ad=4e-14 as=4e-14 pd=6e-07 ps=6e-07 nrd=0 nrs=0 \
 sa=1.72e-06 sb=1.72e-06 sca=0.602605 scb=2.67635e-06 scc=7.14388e-12
mXI4\/XI18\/MNM15 ( N_XI4\/XI18\/NET255_XI4\/XI18\/MNM15_d \
 N_XI4\/XI18\/NET248_XI4\/XI18\/MNM15_g N_XI4\/XI18\/NET252_XI4\/XI18\/MNM15_s \
 N_GND_XI4\/XI18\/MNM6_b ) N_12_LLRVT l=6e-08 w=4e-07 ad=4e-14 as=4e-14 \
 pd=6e-07 ps=6e-07 nrd=0 nrs=0 sa=2.24e-06 sb=1.2e-06 sca=0.602605 \
 scb=2.67635e-06 scc=7.14388e-12
mXI4\/XI18\/MNM19 ( N_XI4\/XI18\/NET261_XI4\/XI18\/MNM19_d \
 N_B\<0\>_XI4\/XI18\/MNM19_g N_XI4\/XI18\/NET260_XI4\/XI18\/MNM19_s \
 N_GND_XI4\/XI18\/MNM6_b ) N_12_LLRVT l=6e-08 w=4e-07 ad=4e-14 as=4e-14 \
 pd=6e-07 ps=6e-07 nrd=0 nrs=0 sa=2.76e-06 sb=6.8e-07 sca=0.602605 \
 scb=2.67635e-06 scc=7.14388e-12
mXI4\/XI18\/MNM20 ( N_XI4\/XI18\/NET260_XI4\/XI18\/MNM20_d \
 N_A\<0\>_XI4\/XI18\/MNM20_g N_GND_XI4\/XI18\/MNM20_s N_GND_XI4\/XI18\/MNM6_b \
 ) N_12_LLRVT l=6e-08 w=4e-07 ad=4e-14 as=4e-14 pd=6e-07 ps=6e-07 nrd=0 nrs=0 \
 sa=3.02e-06 sb=4.2e-07 sca=0.602605 scb=2.67635e-06 scc=7.14388e-12
mXI4\/XI9\/MNM19 ( N_XI4\/XI9\/NET16_XI4\/XI9\/MNM19_d \
 N_B\<1\>_XI4\/XI9\/MNM19_g N_XI4\/XI9\/NET13_XI4\/XI9\/MNM19_s \
 N_GND_XI4\/XI18\/MNM6_b ) N_12_LLRVT l=6e-08 w=4e-07 ad=4e-14 as=4e-14 \
 pd=6e-07 ps=6e-07 nrd=0 nrs=0 sa=2.76e-06 sb=6.8e-07 sca=0.602605 \
 scb=2.67635e-06 scc=7.14388e-12
mXI4\/XI9\/MNM20 ( N_XI4\/XI9\/NET13_XI4\/XI9\/MNM20_d \
 N_A\<1\>_XI4\/XI9\/MNM20_g N_GND_XI4\/XI9\/MNM20_s N_GND_XI4\/XI18\/MNM6_b ) \
 N_12_LLRVT l=6e-08 w=4e-07 ad=4e-14 as=4e-14 pd=6e-07 ps=6e-07 nrd=0 nrs=0 \
 sa=3.02e-06 sb=4.2e-07 sca=0.602605 scb=2.67635e-06 scc=7.14388e-12
mXI4\/XI10\/MNM19 ( N_XI4\/XI10\/NET16_XI4\/XI10\/MNM19_d \
 N_B\<2\>_XI4\/XI10\/MNM19_g N_XI4\/XI10\/NET13_XI4\/XI10\/MNM19_s \
 N_GND_XI4\/XI18\/MNM6_b ) N_12_LLRVT l=6e-08 w=4e-07 ad=4e-14 as=4e-14 \
 pd=6e-07 ps=6e-07 nrd=0 nrs=0 sa=2.76e-06 sb=6.8e-07 sca=0.602605 \
 scb=2.67635e-06 scc=7.14388e-12
mXI4\/XI10\/MNM20 ( N_XI4\/XI10\/NET13_XI4\/XI10\/MNM20_d \
 N_A\<2\>_XI4\/XI10\/MNM20_g N_GND_XI4\/XI10\/MNM20_s N_GND_XI4\/XI18\/MNM6_b \
 ) N_12_LLRVT l=6e-08 w=4e-07 ad=4e-14 as=4e-14 pd=6e-07 ps=6e-07 nrd=0 nrs=0 \
 sa=3.02e-06 sb=4.2e-07 sca=0.602605 scb=2.67635e-06 scc=7.14388e-12
mXI4\/XI11\/MNM19 ( N_XI4\/XI11\/NET16_XI4\/XI11\/MNM19_d \
 N_B\<3\>_XI4\/XI11\/MNM19_g N_XI4\/XI11\/NET13_XI4\/XI11\/MNM19_s \
 N_GND_XI4\/XI18\/MNM6_b ) N_12_LLRVT l=6e-08 w=4e-07 ad=4e-14 as=4e-14 \
 pd=6e-07 ps=6e-07 nrd=0 nrs=0 sa=2.76e-06 sb=6.8e-07 sca=0.602605 \
 scb=2.67635e-06 scc=7.14388e-12
mXI4\/XI11\/MNM20 ( N_XI4\/XI11\/NET13_XI4\/XI11\/MNM20_d \
 N_A\<3\>_XI4\/XI11\/MNM20_g N_GND_XI4\/XI11\/MNM20_s N_GND_XI4\/XI18\/MNM6_b \
 ) N_12_LLRVT l=6e-08 w=4e-07 ad=4e-14 as=4e-14 pd=6e-07 ps=6e-07 nrd=0 nrs=0 \
 sa=3.02e-06 sb=4.2e-07 sca=0.602605 scb=2.67635e-06 scc=7.14388e-12
mXI4\/XI12\/MNM19 ( N_XI4\/XI12\/NET16_XI4\/XI12\/MNM19_d \
 N_B\<4\>_XI4\/XI12\/MNM19_g N_XI4\/XI12\/NET13_XI4\/XI12\/MNM19_s \
 N_GND_XI4\/XI18\/MNM6_b ) N_12_LLRVT l=6e-08 w=4e-07 ad=4e-14 as=4e-14 \
 pd=6e-07 ps=6e-07 nrd=0 nrs=0 sa=2.76e-06 sb=6.8e-07 sca=0.602605 \
 scb=2.67635e-06 scc=7.14388e-12
mXI4\/XI12\/MNM20 ( N_XI4\/XI12\/NET13_XI4\/XI12\/MNM20_d \
 N_A\<4\>_XI4\/XI12\/MNM20_g N_GND_XI4\/XI12\/MNM20_s N_GND_XI4\/XI18\/MNM6_b \
 ) N_12_LLRVT l=6e-08 w=4e-07 ad=4e-14 as=4e-14 pd=6e-07 ps=6e-07 nrd=0 nrs=0 \
 sa=3.02e-06 sb=4.2e-07 sca=0.602605 scb=2.67635e-06 scc=7.14388e-12
mXI4\/XI13\/MNM19 ( N_XI4\/XI13\/NET16_XI4\/XI13\/MNM19_d \
 N_B\<5\>_XI4\/XI13\/MNM19_g N_XI4\/XI13\/NET13_XI4\/XI13\/MNM19_s \
 N_GND_XI4\/XI18\/MNM6_b ) N_12_LLRVT l=6e-08 w=4e-07 ad=4e-14 as=4e-14 \
 pd=6e-07 ps=6e-07 nrd=0 nrs=0 sa=2.76e-06 sb=6.8e-07 sca=0.602605 \
 scb=2.67635e-06 scc=7.14388e-12
mXI4\/XI13\/MNM20 ( N_XI4\/XI13\/NET13_XI4\/XI13\/MNM20_d \
 N_A\<5\>_XI4\/XI13\/MNM20_g N_GND_XI4\/XI13\/MNM20_s N_GND_XI4\/XI18\/MNM6_b \
 ) N_12_LLRVT l=6e-08 w=4e-07 ad=4e-14 as=4e-14 pd=6e-07 ps=6e-07 nrd=0 nrs=0 \
 sa=3.02e-06 sb=4.2e-07 sca=0.602605 scb=2.67635e-06 scc=7.14388e-12
mXI4\/XI14\/MNM19 ( N_XI4\/XI14\/NET16_XI4\/XI14\/MNM19_d \
 N_B\<6\>_XI4\/XI14\/MNM19_g N_XI4\/XI14\/NET13_XI4\/XI14\/MNM19_s \
 N_GND_XI4\/XI18\/MNM6_b ) N_12_LLRVT l=6e-08 w=4e-07 ad=4e-14 as=4e-14 \
 pd=6e-07 ps=6e-07 nrd=0 nrs=0 sa=2.76e-06 sb=6.8e-07 sca=0.602605 \
 scb=2.67635e-06 scc=7.14388e-12
mXI4\/XI14\/MNM20 ( N_XI4\/XI14\/NET13_XI4\/XI14\/MNM20_d \
 N_A\<6\>_XI4\/XI14\/MNM20_g N_GND_XI4\/XI14\/MNM20_s N_GND_XI4\/XI18\/MNM6_b \
 ) N_12_LLRVT l=6e-08 w=4e-07 ad=4e-14 as=4e-14 pd=6e-07 ps=6e-07 nrd=0 nrs=0 \
 sa=3.02e-06 sb=4.2e-07 sca=0.602605 scb=2.67635e-06 scc=7.14388e-12
mXI4\/XI19\/MNM19 ( N_XI4\/XI19\/NET261_XI4\/XI19\/MNM19_d \
 N_B\<7\>_XI4\/XI19\/MNM19_g N_XI4\/XI19\/NET260_XI4\/XI19\/MNM19_s \
 N_GND_XI4\/XI18\/MNM6_b ) N_12_LLRVT l=6e-08 w=4e-07 ad=4e-14 as=4e-14 \
 pd=6e-07 ps=6e-07 nrd=0 nrs=0 sa=2.76e-06 sb=6.8e-07 sca=0.602605 \
 scb=2.67635e-06 scc=7.14388e-12
mXI4\/XI19\/MNM20 ( N_XI4\/XI19\/NET260_XI4\/XI19\/MNM20_d \
 N_A\<7\>_XI4\/XI19\/MNM20_g N_GND_XI4\/XI19\/MNM20_s N_GND_XI4\/XI18\/MNM6_b \
 ) N_12_LLRVT l=6e-08 w=4e-07 ad=4e-14 as=4e-14 pd=6e-07 ps=6e-07 nrd=0 nrs=0 \
 sa=3.02e-06 sb=4.2e-07 sca=0.602605 scb=2.67635e-06 scc=7.14388e-12
mXI4\/XI18\/MNM18 ( N_XI4\/XI18\/NET255_XI4\/XI18\/MNM18_d \
 N_GND_XI4\/XI18\/MNM18_g N_XI4\/XI18\/NET261_XI4\/XI18\/MNM18_s \
 N_GND_XI4\/XI18\/MNM6_b ) N_12_LLRVT l=6e-08 w=4e-07 ad=4e-14 as=4e-14 \
 pd=6e-07 ps=6e-07 nrd=0 nrs=0 sa=2.5e-06 sb=9.4e-07 sca=0.602605 \
 scb=2.67635e-06 scc=7.14388e-12
mXI4\/XI18\/MNM3 ( N_XI4\/XI18\/NET248_XI4\/XI18\/MNM3_d \
 N_A\<0\>_XI4\/XI18\/MNM3_g N_XI4\/XI18\/NET029_XI4\/XI18\/MNM3_s \
 N_GND_XI4\/XI18\/MNM6_b ) N_12_LLRVT l=6e-08 w=4e-07 ad=4e-14 as=4e-14 \
 pd=6e-07 ps=6e-07 nrd=0 nrs=0 sa=9.4e-07 sb=2.5e-06 sca=0.602605 \
 scb=2.67635e-06 scc=7.14388e-12
mXI4\/XI9\/MNM0 ( N_XI4\/XI9\/NET35_XI4\/XI9\/MNM0_d \
 N_XI4\/NET12_XI4\/XI9\/MNM0_g N_XI4\/XI9\/NET51_XI4\/XI9\/MNM0_s \
 N_GND_XI4\/XI18\/MNM6_b ) N_12_LLRVT l=6e-08 w=4e-07 ad=4e-14 as=4e-14 \
 pd=6e-07 ps=6e-07 nrd=0 nrs=0 sa=6.8e-07 sb=2.76e-06 sca=0.602605 \
 scb=2.67635e-06 scc=7.14388e-12
mXI4\/XI9\/MNM16 ( N_XI4\/XI9\/NET35_XI4\/XI9\/MNM16_d \
 N_A\<1\>_XI4\/XI9\/MNM16_g N_XI4\/XI9\/NET4_XI4\/XI9\/MNM16_s \
 N_GND_XI4\/XI18\/MNM6_b ) N_12_LLRVT l=6e-08 w=4e-07 ad=4e-14 as=4e-14 \
 pd=6e-07 ps=6e-07 nrd=0 nrs=0 sa=9.4e-07 sb=2.5e-06 sca=0.602605 \
 scb=2.67635e-06 scc=7.14388e-12
mXI4\/XI9\/MNM15 ( N_XI4\/XI9\/NET7_XI4\/XI9\/MNM15_d \
 N_XI4\/XI9\/NET35_XI4\/XI9\/MNM15_g N_XI4\/XI9\/NET21_XI4\/XI9\/MNM15_s \
 N_GND_XI4\/XI18\/MNM6_b ) N_12_LLRVT l=6e-08 w=4e-07 ad=4e-14 as=4e-14 \
 pd=6e-07 ps=6e-07 nrd=0 nrs=0 sa=2.24e-06 sb=1.2e-06 sca=0.602605 \
 scb=2.67635e-06 scc=7.14388e-12
mXI4\/XI9\/MNM18 ( N_XI4\/XI9\/NET7_XI4\/XI9\/MNM18_d \
 N_XI4\/NET12_XI4\/XI9\/MNM18_g N_XI4\/XI9\/NET16_XI4\/XI9\/MNM18_s \
 N_GND_XI4\/XI18\/MNM6_b ) N_12_LLRVT l=6e-08 w=4e-07 ad=4e-14 as=4e-14 \
 pd=6e-07 ps=6e-07 nrd=0 nrs=0 sa=2.5e-06 sb=9.4e-07 sca=0.602605 \
 scb=2.67635e-06 scc=7.14388e-12
mXI4\/XI10\/MNM0 ( N_XI4\/XI10\/NET35_XI4\/XI10\/MNM0_d \
 N_XI4\/NET16_XI4\/XI10\/MNM0_g N_XI4\/XI10\/NET51_XI4\/XI10\/MNM0_s \
 N_GND_XI4\/XI18\/MNM6_b ) N_12_LLRVT l=6e-08 w=4e-07 ad=4e-14 as=4e-14 \
 pd=6e-07 ps=6e-07 nrd=0 nrs=0 sa=6.8e-07 sb=2.76e-06 sca=0.602605 \
 scb=2.67635e-06 scc=7.14388e-12
mXI4\/XI10\/MNM16 ( N_XI4\/XI10\/NET35_XI4\/XI10\/MNM16_d \
 N_A\<2\>_XI4\/XI10\/MNM16_g N_XI4\/XI10\/NET4_XI4\/XI10\/MNM16_s \
 N_GND_XI4\/XI18\/MNM6_b ) N_12_LLRVT l=6e-08 w=4e-07 ad=4e-14 as=4e-14 \
 pd=6e-07 ps=6e-07 nrd=0 nrs=0 sa=9.4e-07 sb=2.5e-06 sca=0.602605 \
 scb=2.67635e-06 scc=7.14388e-12
mXI4\/XI10\/MNM15 ( N_XI4\/XI10\/NET7_XI4\/XI10\/MNM15_d \
 N_XI4\/XI10\/NET35_XI4\/XI10\/MNM15_g N_XI4\/XI10\/NET21_XI4\/XI10\/MNM15_s \
 N_GND_XI4\/XI18\/MNM6_b ) N_12_LLRVT l=6e-08 w=4e-07 ad=4e-14 as=4e-14 \
 pd=6e-07 ps=6e-07 nrd=0 nrs=0 sa=2.24e-06 sb=1.2e-06 sca=0.602605 \
 scb=2.67635e-06 scc=7.14388e-12
mXI4\/XI10\/MNM18 ( N_XI4\/XI10\/NET7_XI4\/XI10\/MNM18_d \
 N_XI4\/NET16_XI4\/XI10\/MNM18_g N_XI4\/XI10\/NET16_XI4\/XI10\/MNM18_s \
 N_GND_XI4\/XI18\/MNM6_b ) N_12_LLRVT l=6e-08 w=4e-07 ad=4e-14 as=4e-14 \
 pd=6e-07 ps=6e-07 nrd=0 nrs=0 sa=2.5e-06 sb=9.4e-07 sca=0.602605 \
 scb=2.67635e-06 scc=7.14388e-12
mXI4\/XI11\/MNM0 ( N_XI4\/XI11\/NET35_XI4\/XI11\/MNM0_d \
 N_XI4\/NET18_XI4\/XI11\/MNM0_g N_XI4\/XI11\/NET51_XI4\/XI11\/MNM0_s \
 N_GND_XI4\/XI18\/MNM6_b ) N_12_LLRVT l=6e-08 w=4e-07 ad=4e-14 as=4e-14 \
 pd=6e-07 ps=6e-07 nrd=0 nrs=0 sa=6.8e-07 sb=2.76e-06 sca=0.602605 \
 scb=2.67635e-06 scc=7.14388e-12
mXI4\/XI11\/MNM16 ( N_XI4\/XI11\/NET35_XI4\/XI11\/MNM16_d \
 N_A\<3\>_XI4\/XI11\/MNM16_g N_XI4\/XI11\/NET4_XI4\/XI11\/MNM16_s \
 N_GND_XI4\/XI18\/MNM6_b ) N_12_LLRVT l=6e-08 w=4e-07 ad=4e-14 as=4e-14 \
 pd=6e-07 ps=6e-07 nrd=0 nrs=0 sa=9.4e-07 sb=2.5e-06 sca=0.602605 \
 scb=2.67635e-06 scc=7.14388e-12
mXI4\/XI11\/MNM15 ( N_XI4\/XI11\/NET7_XI4\/XI11\/MNM15_d \
 N_XI4\/XI11\/NET35_XI4\/XI11\/MNM15_g N_XI4\/XI11\/NET21_XI4\/XI11\/MNM15_s \
 N_GND_XI4\/XI18\/MNM6_b ) N_12_LLRVT l=6e-08 w=4e-07 ad=4e-14 as=4e-14 \
 pd=6e-07 ps=6e-07 nrd=0 nrs=0 sa=2.24e-06 sb=1.2e-06 sca=0.602605 \
 scb=2.67635e-06 scc=7.14388e-12
mXI4\/XI11\/MNM18 ( N_XI4\/XI11\/NET7_XI4\/XI11\/MNM18_d \
 N_XI4\/NET18_XI4\/XI11\/MNM18_g N_XI4\/XI11\/NET16_XI4\/XI11\/MNM18_s \
 N_GND_XI4\/XI18\/MNM6_b ) N_12_LLRVT l=6e-08 w=4e-07 ad=4e-14 as=4e-14 \
 pd=6e-07 ps=6e-07 nrd=0 nrs=0 sa=2.5e-06 sb=9.4e-07 sca=0.602605 \
 scb=2.67635e-06 scc=7.14388e-12
mXI4\/XI12\/MNM0 ( N_XI4\/XI12\/NET35_XI4\/XI12\/MNM0_d \
 N_XI4\/NET20_XI4\/XI12\/MNM0_g N_XI4\/XI12\/NET51_XI4\/XI12\/MNM0_s \
 N_GND_XI4\/XI18\/MNM6_b ) N_12_LLRVT l=6e-08 w=4e-07 ad=4e-14 as=4e-14 \
 pd=6e-07 ps=6e-07 nrd=0 nrs=0 sa=6.8e-07 sb=2.76e-06 sca=0.602605 \
 scb=2.67635e-06 scc=7.14388e-12
mXI4\/XI12\/MNM16 ( N_XI4\/XI12\/NET35_XI4\/XI12\/MNM16_d \
 N_A\<4\>_XI4\/XI12\/MNM16_g N_XI4\/XI12\/NET4_XI4\/XI12\/MNM16_s \
 N_GND_XI4\/XI18\/MNM6_b ) N_12_LLRVT l=6e-08 w=4e-07 ad=4e-14 as=4e-14 \
 pd=6e-07 ps=6e-07 nrd=0 nrs=0 sa=9.4e-07 sb=2.5e-06 sca=0.602605 \
 scb=2.67635e-06 scc=7.14388e-12
mXI4\/XI12\/MNM15 ( N_XI4\/XI12\/NET7_XI4\/XI12\/MNM15_d \
 N_XI4\/XI12\/NET35_XI4\/XI12\/MNM15_g N_XI4\/XI12\/NET21_XI4\/XI12\/MNM15_s \
 N_GND_XI4\/XI18\/MNM6_b ) N_12_LLRVT l=6e-08 w=4e-07 ad=4e-14 as=4e-14 \
 pd=6e-07 ps=6e-07 nrd=0 nrs=0 sa=2.24e-06 sb=1.2e-06 sca=0.602605 \
 scb=2.67635e-06 scc=7.14388e-12
mXI4\/XI12\/MNM18 ( N_XI4\/XI12\/NET7_XI4\/XI12\/MNM18_d \
 N_XI4\/NET20_XI4\/XI12\/MNM18_g N_XI4\/XI12\/NET16_XI4\/XI12\/MNM18_s \
 N_GND_XI4\/XI18\/MNM6_b ) N_12_LLRVT l=6e-08 w=4e-07 ad=4e-14 as=4e-14 \
 pd=6e-07 ps=6e-07 nrd=0 nrs=0 sa=2.5e-06 sb=9.4e-07 sca=0.602605 \
 scb=2.67635e-06 scc=7.14388e-12
mXI4\/XI13\/MNM0 ( N_XI4\/XI13\/NET35_XI4\/XI13\/MNM0_d \
 N_XI4\/NET22_XI4\/XI13\/MNM0_g N_XI4\/XI13\/NET51_XI4\/XI13\/MNM0_s \
 N_GND_XI4\/XI18\/MNM6_b ) N_12_LLRVT l=6e-08 w=4e-07 ad=4e-14 as=4e-14 \
 pd=6e-07 ps=6e-07 nrd=0 nrs=0 sa=6.8e-07 sb=2.76e-06 sca=0.602605 \
 scb=2.67635e-06 scc=7.14388e-12
mXI4\/XI13\/MNM16 ( N_XI4\/XI13\/NET35_XI4\/XI13\/MNM16_d \
 N_A\<5\>_XI4\/XI13\/MNM16_g N_XI4\/XI13\/NET4_XI4\/XI13\/MNM16_s \
 N_GND_XI4\/XI18\/MNM6_b ) N_12_LLRVT l=6e-08 w=4e-07 ad=4e-14 as=4e-14 \
 pd=6e-07 ps=6e-07 nrd=0 nrs=0 sa=9.4e-07 sb=2.5e-06 sca=0.602605 \
 scb=2.67635e-06 scc=7.14388e-12
mXI4\/XI13\/MNM15 ( N_XI4\/XI13\/NET7_XI4\/XI13\/MNM15_d \
 N_XI4\/XI13\/NET35_XI4\/XI13\/MNM15_g N_XI4\/XI13\/NET21_XI4\/XI13\/MNM15_s \
 N_GND_XI4\/XI18\/MNM6_b ) N_12_LLRVT l=6e-08 w=4e-07 ad=4e-14 as=4e-14 \
 pd=6e-07 ps=6e-07 nrd=0 nrs=0 sa=2.24e-06 sb=1.2e-06 sca=0.602605 \
 scb=2.67635e-06 scc=7.14388e-12
mXI4\/XI13\/MNM18 ( N_XI4\/XI13\/NET7_XI4\/XI13\/MNM18_d \
 N_XI4\/NET22_XI4\/XI13\/MNM18_g N_XI4\/XI13\/NET16_XI4\/XI13\/MNM18_s \
 N_GND_XI4\/XI18\/MNM6_b ) N_12_LLRVT l=6e-08 w=4e-07 ad=4e-14 as=4e-14 \
 pd=6e-07 ps=6e-07 nrd=0 nrs=0 sa=2.5e-06 sb=9.4e-07 sca=0.602605 \
 scb=2.67635e-06 scc=7.14388e-12
mXI4\/XI14\/MNM0 ( N_XI4\/XI14\/NET35_XI4\/XI14\/MNM0_d \
 N_XI4\/NET24_XI4\/XI14\/MNM0_g N_XI4\/XI14\/NET51_XI4\/XI14\/MNM0_s \
 N_GND_XI4\/XI18\/MNM6_b ) N_12_LLRVT l=6e-08 w=4e-07 ad=4e-14 as=4e-14 \
 pd=6e-07 ps=6e-07 nrd=0 nrs=0 sa=6.8e-07 sb=2.76e-06 sca=0.602605 \
 scb=2.67635e-06 scc=7.14388e-12
mXI4\/XI14\/MNM16 ( N_XI4\/XI14\/NET35_XI4\/XI14\/MNM16_d \
 N_A\<6\>_XI4\/XI14\/MNM16_g N_XI4\/XI14\/NET4_XI4\/XI14\/MNM16_s \
 N_GND_XI4\/XI18\/MNM6_b ) N_12_LLRVT l=6e-08 w=4e-07 ad=4e-14 as=4e-14 \
 pd=6e-07 ps=6e-07 nrd=0 nrs=0 sa=9.4e-07 sb=2.5e-06 sca=0.602605 \
 scb=2.67635e-06 scc=7.14388e-12
mXI4\/XI14\/MNM15 ( N_XI4\/XI14\/NET7_XI4\/XI14\/MNM15_d \
 N_XI4\/XI14\/NET35_XI4\/XI14\/MNM15_g N_XI4\/XI14\/NET21_XI4\/XI14\/MNM15_s \
 N_GND_XI4\/XI18\/MNM6_b ) N_12_LLRVT l=6e-08 w=4e-07 ad=4e-14 as=4e-14 \
 pd=6e-07 ps=6e-07 nrd=0 nrs=0 sa=2.24e-06 sb=1.2e-06 sca=0.602605 \
 scb=2.67635e-06 scc=7.14388e-12
mXI4\/XI14\/MNM18 ( N_XI4\/XI14\/NET7_XI4\/XI14\/MNM18_d \
 N_XI4\/NET24_XI4\/XI14\/MNM18_g N_XI4\/XI14\/NET16_XI4\/XI14\/MNM18_s \
 N_GND_XI4\/XI18\/MNM6_b ) N_12_LLRVT l=6e-08 w=4e-07 ad=4e-14 as=4e-14 \
 pd=6e-07 ps=6e-07 nrd=0 nrs=0 sa=2.5e-06 sb=9.4e-07 sca=0.602605 \
 scb=2.67635e-06 scc=7.14388e-12
mXI4\/XI19\/MNM0 ( N_XI4\/XI19\/NET248_XI4\/XI19\/MNM0_d \
 N_XI4\/NET26_XI4\/XI19\/MNM0_g N_XI4\/XI19\/NET246_XI4\/XI19\/MNM0_s \
 N_GND_XI4\/XI18\/MNM6_b ) N_12_LLRVT l=6e-08 w=4e-07 ad=4e-14 as=4e-14 \
 pd=6e-07 ps=6e-07 nrd=0 nrs=0 sa=6.8e-07 sb=2.76e-06 sca=0.602605 \
 scb=2.67635e-06 scc=7.14388e-12
mXI4\/XI19\/MNM16 ( N_XI4\/XI19\/NET248_XI4\/XI19\/MNM16_d \
 N_A\<7\>_XI4\/XI19\/MNM16_g N_XI4\/XI19\/NET262_XI4\/XI19\/MNM16_s \
 N_GND_XI4\/XI18\/MNM6_b ) N_12_LLRVT l=6e-08 w=4e-07 ad=4e-14 as=4e-14 \
 pd=6e-07 ps=6e-07 nrd=0 nrs=0 sa=9.4e-07 sb=2.5e-06 sca=0.602605 \
 scb=2.67635e-06 scc=7.14388e-12
mXI4\/XI19\/MNM15 ( N_XI4\/XI19\/NET255_XI4\/XI19\/MNM15_d \
 N_XI4\/XI19\/NET248_XI4\/XI19\/MNM15_g N_XI4\/XI19\/NET252_XI4\/XI19\/MNM15_s \
 N_GND_XI4\/XI18\/MNM6_b ) N_12_LLRVT l=6e-08 w=4e-07 ad=4e-14 as=4e-14 \
 pd=6e-07 ps=6e-07 nrd=0 nrs=0 sa=2.24e-06 sb=1.2e-06 sca=0.602605 \
 scb=2.67635e-06 scc=7.14388e-12
mXI4\/XI19\/MNM18 ( N_XI4\/XI19\/NET255_XI4\/XI19\/MNM18_d \
 N_XI4\/NET26_XI4\/XI19\/MNM18_g N_XI4\/XI19\/NET261_XI4\/XI19\/MNM18_s \
 N_GND_XI4\/XI18\/MNM6_b ) N_12_LLRVT l=6e-08 w=4e-07 ad=4e-14 as=4e-14 \
 pd=6e-07 ps=6e-07 nrd=0 nrs=0 sa=2.5e-06 sb=9.4e-07 sca=0.602605 \
 scb=2.67635e-06 scc=7.14388e-12
mXI4\/XI18\/MNM1 ( N_XI4\/XI18\/NET246_XI4\/XI18\/MNM1_d \
 N_A\<0\>_XI4\/XI18\/MNM1_g N_GND_XI4\/XI18\/MNM1_s N_GND_XI4\/XI18\/MNM6_b ) \
 N_12_LLRVT l=6e-08 w=4e-07 ad=4e-14 as=4e-14 pd=6e-07 ps=6e-07 nrd=0 nrs=0 \
 sa=4.2e-07 sb=3.02e-06 sca=0.602605 scb=2.67635e-06 scc=7.14388e-12
mXI4\/XI18\/MNM4 ( N_XI4\/XI18\/NET029_XI4\/XI18\/MNM4_d \
 N_B\<0\>_XI4\/XI18\/MNM4_g N_GND_XI4\/XI18\/MNM4_s N_GND_XI4\/XI18\/MNM6_b ) \
 N_12_LLRVT l=6e-08 w=4e-07 ad=4e-14 as=4e-14 pd=6e-07 ps=6e-07 nrd=0 nrs=0 \
 sa=1.2e-06 sb=2.24e-06 sca=0.602605 scb=2.67635e-06 scc=7.14388e-12
mXI4\/XI9\/MNM17 ( N_XI4\/XI9\/NET4_XI4\/XI9\/MNM17_d \
 N_B\<1\>_XI4\/XI9\/MNM17_g N_GND_XI4\/XI9\/MNM17_s N_GND_XI4\/XI18\/MNM6_b ) \
 N_12_LLRVT l=6e-08 w=4e-07 ad=4e-14 as=4e-14 pd=6e-07 ps=6e-07 nrd=0 nrs=0 \
 sa=1.2e-06 sb=2.24e-06 sca=0.602605 scb=2.67635e-06 scc=7.14388e-12
mXI4\/XI10\/MNM17 ( N_XI4\/XI10\/NET4_XI4\/XI10\/MNM17_d \
 N_B\<2\>_XI4\/XI10\/MNM17_g N_GND_XI4\/XI10\/MNM17_s N_GND_XI4\/XI18\/MNM6_b \
 ) N_12_LLRVT l=6e-08 w=4e-07 ad=4e-14 as=4e-14 pd=6e-07 ps=6e-07 nrd=0 nrs=0 \
 sa=1.2e-06 sb=2.24e-06 sca=0.602605 scb=2.67635e-06 scc=7.14388e-12
mXI4\/XI11\/MNM17 ( N_XI4\/XI11\/NET4_XI4\/XI11\/MNM17_d \
 N_B\<3\>_XI4\/XI11\/MNM17_g N_GND_XI4\/XI11\/MNM17_s N_GND_XI4\/XI18\/MNM6_b \
 ) N_12_LLRVT l=6e-08 w=4e-07 ad=4e-14 as=4e-14 pd=6e-07 ps=6e-07 nrd=0 nrs=0 \
 sa=1.2e-06 sb=2.24e-06 sca=0.602605 scb=2.67635e-06 scc=7.14388e-12
mXI4\/XI12\/MNM17 ( N_XI4\/XI12\/NET4_XI4\/XI12\/MNM17_d \
 N_B\<4\>_XI4\/XI12\/MNM17_g N_GND_XI4\/XI12\/MNM17_s N_GND_XI4\/XI18\/MNM6_b \
 ) N_12_LLRVT l=6e-08 w=4e-07 ad=4e-14 as=4e-14 pd=6e-07 ps=6e-07 nrd=0 nrs=0 \
 sa=1.2e-06 sb=2.24e-06 sca=0.602605 scb=2.67635e-06 scc=7.14388e-12
mXI4\/XI13\/MNM17 ( N_XI4\/XI13\/NET4_XI4\/XI13\/MNM17_d \
 N_B\<5\>_XI4\/XI13\/MNM17_g N_GND_XI4\/XI13\/MNM17_s N_GND_XI4\/XI18\/MNM6_b \
 ) N_12_LLRVT l=6e-08 w=4e-07 ad=4e-14 as=4e-14 pd=6e-07 ps=6e-07 nrd=0 nrs=0 \
 sa=1.2e-06 sb=2.24e-06 sca=0.602605 scb=2.67635e-06 scc=7.14388e-12
mXI4\/XI14\/MNM17 ( N_XI4\/XI14\/NET4_XI4\/XI14\/MNM17_d \
 N_B\<6\>_XI4\/XI14\/MNM17_g N_GND_XI4\/XI14\/MNM17_s N_GND_XI4\/XI18\/MNM6_b \
 ) N_12_LLRVT l=6e-08 w=4e-07 ad=4e-14 as=4e-14 pd=6e-07 ps=6e-07 nrd=0 nrs=0 \
 sa=1.2e-06 sb=2.24e-06 sca=0.602605 scb=2.67635e-06 scc=7.14388e-12
mXI4\/XI19\/MNM17 ( N_XI4\/XI19\/NET262_XI4\/XI19\/MNM17_d \
 N_B\<7\>_XI4\/XI19\/MNM17_g N_GND_XI4\/XI19\/MNM17_s N_GND_XI4\/XI18\/MNM6_b \
 ) N_12_LLRVT l=6e-08 w=4e-07 ad=4e-14 as=4e-14 pd=6e-07 ps=6e-07 nrd=0 nrs=0 \
 sa=1.2e-06 sb=2.24e-06 sca=0.602605 scb=2.67635e-06 scc=7.14388e-12
mXI4\/XI18\/MPM22 ( N_XI4\/XI18\/NET253_XI4\/XI18\/MPM22_d \
 N_A\<0\>_XI4\/XI18\/MPM22_g N_VDD_XI4\/XI18\/MPM22_s N_VDD_XI4\/XI18\/MPM0_b \
 ) P_12_LLRVT l=6e-08 w=8e-07 ad=8e-14 as=8e-14 pd=1e-06 ps=1e-06 nrd=0 nrs=0 \
 sa=1.46e-06 sb=1.98e-06 sca=34.1152 scb=0.0233305 scc=0.00354076
mXI4\/XI18\/MPM23 ( N_XI4\/XI18\/NET253_XI4\/XI18\/MPM23_d \
 N_B\<0\>_XI4\/XI18\/MPM23_g N_VDD_XI4\/XI18\/MPM23_s N_VDD_XI4\/XI18\/MPM0_b \
 ) P_12_LLRVT l=6e-08 w=8e-07 ad=8e-14 as=8e-14 pd=1e-06 ps=1e-06 nrd=0 nrs=0 \
 sa=1.72e-06 sb=1.72e-06 sca=33.8408 scb=0.0231782 scc=0.0035407
mXI4\/XI18\/MPM24 ( N_XI4\/XI18\/NET253_XI4\/XI18\/MPM24_d \
 N_GND_XI4\/XI18\/MPM24_g N_VDD_XI4\/XI18\/MPM24_s N_VDD_XI4\/XI18\/MPM0_b ) \
 P_12_LLRVT l=6e-08 w=8e-07 ad=8e-14 as=8e-14 pd=1e-06 ps=1e-06 nrd=0 nrs=0 \
 sa=1.98e-06 sb=1.46e-06 sca=33.7323 scb=0.0231364 scc=0.00354069
mXI4\/XI18\/MPM33 ( N_XI4\/XI18\/NET255_XI4\/XI18\/MPM33_d \
 N_GND_XI4\/XI18\/MPM33_g N_XI4\/XI18\/NET258_XI4\/XI18\/MPM33_s \
 N_VDD_XI4\/XI18\/MPM0_b ) P_12_LLRVT l=6e-08 w=8e-07 ad=8e-14 as=8e-14 \
 pd=1e-06 ps=1e-06 nrd=0 nrs=0 sa=2.5e-06 sb=9.4e-07 sca=33.9234 scb=0.0232171 \
 scc=0.00354071
mXI4\/XI18\/MPM32 ( N_XI4\/XI18\/NET258_XI4\/XI18\/MPM32_d \
 N_B\<0\>_XI4\/XI18\/MPM32_g N_XI4\/XI18\/NET257_XI4\/XI18\/MPM32_s \
 N_VDD_XI4\/XI18\/MPM0_b ) P_12_LLRVT l=6e-08 w=8e-07 ad=8e-14 as=8e-14 \
 pd=1e-06 ps=1e-06 nrd=0 nrs=0 sa=2.76e-06 sb=6.8e-07 sca=34.2816 \
 scb=0.0234539 scc=0.00354085
mXI4\/XI18\/MPM31 ( N_XI4\/XI18\/NET257_XI4\/XI18\/MPM31_d \
 N_A\<0\>_XI4\/XI18\/MPM31_g N_VDD_XI4\/XI18\/MPM31_s N_VDD_XI4\/XI18\/MPM0_b \
 ) P_12_LLRVT l=6e-08 w=8e-07 ad=8e-14 as=8e-14 pd=1e-06 ps=1e-06 nrd=0 nrs=0 \
 sa=3.02e-06 sb=4.2e-07 sca=34.9649 scb=0.02417 scc=0.00354248
mXI4\/XI9\/MPM32 ( N_XI4\/XI9\/NET031_XI4\/XI9\/MPM32_d \
 N_B\<1\>_XI4\/XI9\/MPM32_g N_XI4\/XI9\/NET032_XI4\/XI9\/MPM32_s \
 N_VDD_XI4\/XI18\/MPM0_b ) P_12_LLRVT l=6e-08 w=8e-07 ad=8e-14 as=8e-14 \
 pd=1e-06 ps=1e-06 nrd=0 nrs=0 sa=2.76e-06 sb=6.8e-07 sca=34.2816 \
 scb=0.0234539 scc=0.00354085
mXI4\/XI9\/MPM31 ( N_XI4\/XI9\/NET032_XI4\/XI9\/MPM31_d \
 N_A\<1\>_XI4\/XI9\/MPM31_g N_VDD_XI4\/XI9\/MPM31_s N_VDD_XI4\/XI18\/MPM0_b ) \
 P_12_LLRVT l=6e-08 w=8e-07 ad=8e-14 as=8e-14 pd=1e-06 ps=1e-06 nrd=0 nrs=0 \
 sa=3.02e-06 sb=4.2e-07 sca=34.9649 scb=0.02417 scc=0.00354248
mXI4\/XI10\/MPM32 ( N_XI4\/XI10\/NET031_XI4\/XI10\/MPM32_d \
 N_B\<2\>_XI4\/XI10\/MPM32_g N_XI4\/XI10\/NET032_XI4\/XI10\/MPM32_s \
 N_VDD_XI4\/XI18\/MPM0_b ) P_12_LLRVT l=6e-08 w=8e-07 ad=8e-14 as=8e-14 \
 pd=1e-06 ps=1e-06 nrd=0 nrs=0 sa=2.76e-06 sb=6.8e-07 sca=34.2816 \
 scb=0.0234539 scc=0.00354085
mXI4\/XI10\/MPM31 ( N_XI4\/XI10\/NET032_XI4\/XI10\/MPM31_d \
 N_A\<2\>_XI4\/XI10\/MPM31_g N_VDD_XI4\/XI10\/MPM31_s N_VDD_XI4\/XI18\/MPM0_b \
 ) P_12_LLRVT l=6e-08 w=8e-07 ad=8e-14 as=8e-14 pd=1e-06 ps=1e-06 nrd=0 nrs=0 \
 sa=3.02e-06 sb=4.2e-07 sca=34.9649 scb=0.02417 scc=0.00354248
mXI4\/XI11\/MPM32 ( N_XI4\/XI11\/NET031_XI4\/XI11\/MPM32_d \
 N_B\<3\>_XI4\/XI11\/MPM32_g N_XI4\/XI11\/NET032_XI4\/XI11\/MPM32_s \
 N_VDD_XI4\/XI18\/MPM0_b ) P_12_LLRVT l=6e-08 w=8e-07 ad=8e-14 as=8e-14 \
 pd=1e-06 ps=1e-06 nrd=0 nrs=0 sa=2.76e-06 sb=6.8e-07 sca=34.2816 \
 scb=0.0234539 scc=0.00354085
mXI4\/XI11\/MPM31 ( N_XI4\/XI11\/NET032_XI4\/XI11\/MPM31_d \
 N_A\<3\>_XI4\/XI11\/MPM31_g N_VDD_XI4\/XI11\/MPM31_s N_VDD_XI4\/XI18\/MPM0_b \
 ) P_12_LLRVT l=6e-08 w=8e-07 ad=8e-14 as=8e-14 pd=1e-06 ps=1e-06 nrd=0 nrs=0 \
 sa=3.02e-06 sb=4.2e-07 sca=34.9649 scb=0.02417 scc=0.00354248
mXI4\/XI12\/MPM32 ( N_XI4\/XI12\/NET031_XI4\/XI12\/MPM32_d \
 N_B\<4\>_XI4\/XI12\/MPM32_g N_XI4\/XI12\/NET032_XI4\/XI12\/MPM32_s \
 N_VDD_XI4\/XI18\/MPM0_b ) P_12_LLRVT l=6e-08 w=8e-07 ad=8e-14 as=8e-14 \
 pd=1e-06 ps=1e-06 nrd=0 nrs=0 sa=2.76e-06 sb=6.8e-07 sca=34.2816 \
 scb=0.0234539 scc=0.00354085
mXI4\/XI12\/MPM31 ( N_XI4\/XI12\/NET032_XI4\/XI12\/MPM31_d \
 N_A\<4\>_XI4\/XI12\/MPM31_g N_VDD_XI4\/XI12\/MPM31_s N_VDD_XI4\/XI18\/MPM0_b \
 ) P_12_LLRVT l=6e-08 w=8e-07 ad=8e-14 as=8e-14 pd=1e-06 ps=1e-06 nrd=0 nrs=0 \
 sa=3.02e-06 sb=4.2e-07 sca=34.9649 scb=0.02417 scc=0.00354248
mXI4\/XI13\/MPM32 ( N_XI4\/XI13\/NET031_XI4\/XI13\/MPM32_d \
 N_B\<5\>_XI4\/XI13\/MPM32_g N_XI4\/XI13\/NET032_XI4\/XI13\/MPM32_s \
 N_VDD_XI4\/XI18\/MPM0_b ) P_12_LLRVT l=6e-08 w=8e-07 ad=8e-14 as=8e-14 \
 pd=1e-06 ps=1e-06 nrd=0 nrs=0 sa=2.76e-06 sb=6.8e-07 sca=34.2816 \
 scb=0.0234539 scc=0.00354085
mXI4\/XI13\/MPM31 ( N_XI4\/XI13\/NET032_XI4\/XI13\/MPM31_d \
 N_A\<5\>_XI4\/XI13\/MPM31_g N_VDD_XI4\/XI13\/MPM31_s N_VDD_XI4\/XI18\/MPM0_b \
 ) P_12_LLRVT l=6e-08 w=8e-07 ad=8e-14 as=8e-14 pd=1e-06 ps=1e-06 nrd=0 nrs=0 \
 sa=3.02e-06 sb=4.2e-07 sca=34.9649 scb=0.02417 scc=0.00354248
mXI4\/XI14\/MPM32 ( N_XI4\/XI14\/NET031_XI4\/XI14\/MPM32_d \
 N_B\<6\>_XI4\/XI14\/MPM32_g N_XI4\/XI14\/NET032_XI4\/XI14\/MPM32_s \
 N_VDD_XI4\/XI18\/MPM0_b ) P_12_LLRVT l=6e-08 w=8e-07 ad=8e-14 as=8e-14 \
 pd=1e-06 ps=1e-06 nrd=0 nrs=0 sa=2.76e-06 sb=6.8e-07 sca=34.2816 \
 scb=0.0234539 scc=0.00354085
mXI4\/XI14\/MPM31 ( N_XI4\/XI14\/NET032_XI4\/XI14\/MPM31_d \
 N_A\<6\>_XI4\/XI14\/MPM31_g N_VDD_XI4\/XI14\/MPM31_s N_VDD_XI4\/XI18\/MPM0_b \
 ) P_12_LLRVT l=6e-08 w=8e-07 ad=8e-14 as=8e-14 pd=1e-06 ps=1e-06 nrd=0 nrs=0 \
 sa=3.02e-06 sb=4.2e-07 sca=34.9649 scb=0.02417 scc=0.00354248
mXI4\/XI19\/MPM32 ( N_XI4\/XI19\/NET258_XI4\/XI19\/MPM32_d \
 N_B\<7\>_XI4\/XI19\/MPM32_g N_XI4\/XI19\/NET257_XI4\/XI19\/MPM32_s \
 N_VDD_XI4\/XI18\/MPM0_b ) P_12_LLRVT l=6e-08 w=8e-07 ad=8e-14 as=8e-14 \
 pd=1e-06 ps=1e-06 nrd=0 nrs=0 sa=2.76e-06 sb=6.8e-07 sca=34.2816 \
 scb=0.0234539 scc=0.00354085
mXI4\/XI19\/MPM31 ( N_XI4\/XI19\/NET257_XI4\/XI19\/MPM31_d \
 N_A\<7\>_XI4\/XI19\/MPM31_g N_VDD_XI4\/XI19\/MPM31_s N_VDD_XI4\/XI18\/MPM0_b \
 ) P_12_LLRVT l=6e-08 w=8e-07 ad=8e-14 as=8e-14 pd=1e-06 ps=1e-06 nrd=0 nrs=0 \
 sa=3.02e-06 sb=4.2e-07 sca=34.9649 scb=0.02417 scc=0.00354248
mXI4\/XI18\/MPM30 ( N_XI4\/XI18\/NET248_XI4\/XI18\/MPM30_d \
 N_A\<0\>_XI4\/XI18\/MPM30_g N_XI4\/XI18\/NET259_XI4\/XI18\/MPM30_s \
 N_VDD_XI4\/XI18\/MPM0_b ) P_12_LLRVT l=6e-08 w=8e-07 ad=8e-14 as=8e-14 \
 pd=1e-06 ps=1e-06 nrd=0 nrs=0 sa=9.4e-07 sb=2.5e-06 sca=35.6769 scb=0.0251795 \
 scc=0.00354845
mXI4\/XI9\/MPM16 ( N_XI4\/XI9\/NET35_XI4\/XI9\/MPM16_d \
 N_XI4\/NET12_XI4\/XI9\/MPM16_g N_XI4\/XI9\/NET06_XI4\/XI9\/MPM16_s \
 N_VDD_XI4\/XI18\/MPM0_b ) P_12_LLRVT l=6e-08 w=8e-07 ad=8e-14 as=8e-14 \
 pd=1e-06 ps=1e-06 nrd=0 nrs=0 sa=6.8e-07 sb=2.76e-06 sca=37.8517 \
 scb=0.0289498 scc=0.00362077
mXI4\/XI9\/MPM30 ( N_XI4\/XI9\/NET35_XI4\/XI9\/MPM30_d \
 N_A\<1\>_XI4\/XI9\/MPM30_g N_XI4\/XI9\/NET033_XI4\/XI9\/MPM30_s \
 N_VDD_XI4\/XI18\/MPM0_b ) P_12_LLRVT l=6e-08 w=8e-07 ad=8e-14 as=8e-14 \
 pd=1e-06 ps=1e-06 nrd=0 nrs=0 sa=9.4e-07 sb=2.5e-06 sca=35.6769 scb=0.0251795 \
 scc=0.00354845
mXI4\/XI9\/MPM21 ( N_XI4\/XI9\/NET7_XI4\/XI9\/MPM21_d \
 N_XI4\/XI9\/NET35_XI4\/XI9\/MPM21_g N_XI4\/XI9\/NET015_XI4\/XI9\/MPM21_s \
 N_VDD_XI4\/XI18\/MPM0_b ) P_12_LLRVT l=6e-08 w=8e-07 ad=8e-14 as=8e-14 \
 pd=1e-06 ps=1e-06 nrd=0 nrs=0 sa=2.24e-06 sb=1.2e-06 sca=33.7574 \
 scb=0.0231451 scc=0.00354069
mXI4\/XI9\/MPM33 ( N_XI4\/XI9\/NET7_XI4\/XI9\/MPM33_d \
 N_XI4\/NET12_XI4\/XI9\/MPM33_g N_XI4\/XI9\/NET031_XI4\/XI9\/MPM33_s \
 N_VDD_XI4\/XI18\/MPM0_b ) P_12_LLRVT l=6e-08 w=8e-07 ad=8e-14 as=8e-14 \
 pd=1e-06 ps=1e-06 nrd=0 nrs=0 sa=2.5e-06 sb=9.4e-07 sca=33.9234 scb=0.0232171 \
 scc=0.00354071
mXI4\/XI10\/MPM16 ( N_XI4\/XI10\/NET35_XI4\/XI10\/MPM16_d \
 N_XI4\/NET16_XI4\/XI10\/MPM16_g N_XI4\/XI10\/NET06_XI4\/XI10\/MPM16_s \
 N_VDD_XI4\/XI18\/MPM0_b ) P_12_LLRVT l=6e-08 w=8e-07 ad=8e-14 as=8e-14 \
 pd=1e-06 ps=1e-06 nrd=0 nrs=0 sa=6.8e-07 sb=2.76e-06 sca=37.8517 \
 scb=0.0289498 scc=0.00362077
mXI4\/XI10\/MPM30 ( N_XI4\/XI10\/NET35_XI4\/XI10\/MPM30_d \
 N_A\<2\>_XI4\/XI10\/MPM30_g N_XI4\/XI10\/NET033_XI4\/XI10\/MPM30_s \
 N_VDD_XI4\/XI18\/MPM0_b ) P_12_LLRVT l=6e-08 w=8e-07 ad=8e-14 as=8e-14 \
 pd=1e-06 ps=1e-06 nrd=0 nrs=0 sa=9.4e-07 sb=2.5e-06 sca=35.6769 scb=0.0251795 \
 scc=0.00354845
mXI4\/XI10\/MPM21 ( N_XI4\/XI10\/NET7_XI4\/XI10\/MPM21_d \
 N_XI4\/XI10\/NET35_XI4\/XI10\/MPM21_g N_XI4\/XI10\/NET015_XI4\/XI10\/MPM21_s \
 N_VDD_XI4\/XI18\/MPM0_b ) P_12_LLRVT l=6e-08 w=8e-07 ad=8e-14 as=8e-14 \
 pd=1e-06 ps=1e-06 nrd=0 nrs=0 sa=2.24e-06 sb=1.2e-06 sca=33.7574 \
 scb=0.0231451 scc=0.00354069
mXI4\/XI10\/MPM33 ( N_XI4\/XI10\/NET7_XI4\/XI10\/MPM33_d \
 N_XI4\/NET16_XI4\/XI10\/MPM33_g N_XI4\/XI10\/NET031_XI4\/XI10\/MPM33_s \
 N_VDD_XI4\/XI18\/MPM0_b ) P_12_LLRVT l=6e-08 w=8e-07 ad=8e-14 as=8e-14 \
 pd=1e-06 ps=1e-06 nrd=0 nrs=0 sa=2.5e-06 sb=9.4e-07 sca=33.9234 scb=0.0232171 \
 scc=0.00354071
mXI4\/XI11\/MPM16 ( N_XI4\/XI11\/NET35_XI4\/XI11\/MPM16_d \
 N_XI4\/NET18_XI4\/XI11\/MPM16_g N_XI4\/XI11\/NET06_XI4\/XI11\/MPM16_s \
 N_VDD_XI4\/XI18\/MPM0_b ) P_12_LLRVT l=6e-08 w=8e-07 ad=8e-14 as=8e-14 \
 pd=1e-06 ps=1e-06 nrd=0 nrs=0 sa=6.8e-07 sb=2.76e-06 sca=37.8517 \
 scb=0.0289498 scc=0.00362077
mXI4\/XI11\/MPM30 ( N_XI4\/XI11\/NET35_XI4\/XI11\/MPM30_d \
 N_A\<3\>_XI4\/XI11\/MPM30_g N_XI4\/XI11\/NET033_XI4\/XI11\/MPM30_s \
 N_VDD_XI4\/XI18\/MPM0_b ) P_12_LLRVT l=6e-08 w=8e-07 ad=8e-14 as=8e-14 \
 pd=1e-06 ps=1e-06 nrd=0 nrs=0 sa=9.4e-07 sb=2.5e-06 sca=35.6769 scb=0.0251795 \
 scc=0.00354845
mXI4\/XI11\/MPM21 ( N_XI4\/XI11\/NET7_XI4\/XI11\/MPM21_d \
 N_XI4\/XI11\/NET35_XI4\/XI11\/MPM21_g N_XI4\/XI11\/NET015_XI4\/XI11\/MPM21_s \
 N_VDD_XI4\/XI18\/MPM0_b ) P_12_LLRVT l=6e-08 w=8e-07 ad=8e-14 as=8e-14 \
 pd=1e-06 ps=1e-06 nrd=0 nrs=0 sa=2.24e-06 sb=1.2e-06 sca=33.7574 \
 scb=0.0231451 scc=0.00354069
mXI4\/XI11\/MPM33 ( N_XI4\/XI11\/NET7_XI4\/XI11\/MPM33_d \
 N_XI4\/NET18_XI4\/XI11\/MPM33_g N_XI4\/XI11\/NET031_XI4\/XI11\/MPM33_s \
 N_VDD_XI4\/XI18\/MPM0_b ) P_12_LLRVT l=6e-08 w=8e-07 ad=8e-14 as=8e-14 \
 pd=1e-06 ps=1e-06 nrd=0 nrs=0 sa=2.5e-06 sb=9.4e-07 sca=33.9234 scb=0.0232171 \
 scc=0.00354071
mXI4\/XI12\/MPM16 ( N_XI4\/XI12\/NET35_XI4\/XI12\/MPM16_d \
 N_XI4\/NET20_XI4\/XI12\/MPM16_g N_XI4\/XI12\/NET06_XI4\/XI12\/MPM16_s \
 N_VDD_XI4\/XI18\/MPM0_b ) P_12_LLRVT l=6e-08 w=8e-07 ad=8e-14 as=8e-14 \
 pd=1e-06 ps=1e-06 nrd=0 nrs=0 sa=6.8e-07 sb=2.76e-06 sca=37.8517 \
 scb=0.0289498 scc=0.00362077
mXI4\/XI12\/MPM30 ( N_XI4\/XI12\/NET35_XI4\/XI12\/MPM30_d \
 N_A\<4\>_XI4\/XI12\/MPM30_g N_XI4\/XI12\/NET033_XI4\/XI12\/MPM30_s \
 N_VDD_XI4\/XI18\/MPM0_b ) P_12_LLRVT l=6e-08 w=8e-07 ad=8e-14 as=8e-14 \
 pd=1e-06 ps=1e-06 nrd=0 nrs=0 sa=9.4e-07 sb=2.5e-06 sca=35.6769 scb=0.0251795 \
 scc=0.00354845
mXI4\/XI12\/MPM21 ( N_XI4\/XI12\/NET7_XI4\/XI12\/MPM21_d \
 N_XI4\/XI12\/NET35_XI4\/XI12\/MPM21_g N_XI4\/XI12\/NET015_XI4\/XI12\/MPM21_s \
 N_VDD_XI4\/XI18\/MPM0_b ) P_12_LLRVT l=6e-08 w=8e-07 ad=8e-14 as=8e-14 \
 pd=1e-06 ps=1e-06 nrd=0 nrs=0 sa=2.24e-06 sb=1.2e-06 sca=33.7574 \
 scb=0.0231451 scc=0.00354069
mXI4\/XI12\/MPM33 ( N_XI4\/XI12\/NET7_XI4\/XI12\/MPM33_d \
 N_XI4\/NET20_XI4\/XI12\/MPM33_g N_XI4\/XI12\/NET031_XI4\/XI12\/MPM33_s \
 N_VDD_XI4\/XI18\/MPM0_b ) P_12_LLRVT l=6e-08 w=8e-07 ad=8e-14 as=8e-14 \
 pd=1e-06 ps=1e-06 nrd=0 nrs=0 sa=2.5e-06 sb=9.4e-07 sca=33.9234 scb=0.0232171 \
 scc=0.00354071
mXI4\/XI13\/MPM16 ( N_XI4\/XI13\/NET35_XI4\/XI13\/MPM16_d \
 N_XI4\/NET22_XI4\/XI13\/MPM16_g N_XI4\/XI13\/NET06_XI4\/XI13\/MPM16_s \
 N_VDD_XI4\/XI18\/MPM0_b ) P_12_LLRVT l=6e-08 w=8e-07 ad=8e-14 as=8e-14 \
 pd=1e-06 ps=1e-06 nrd=0 nrs=0 sa=6.8e-07 sb=2.76e-06 sca=37.8517 \
 scb=0.0289498 scc=0.00362077
mXI4\/XI13\/MPM30 ( N_XI4\/XI13\/NET35_XI4\/XI13\/MPM30_d \
 N_A\<5\>_XI4\/XI13\/MPM30_g N_XI4\/XI13\/NET033_XI4\/XI13\/MPM30_s \
 N_VDD_XI4\/XI18\/MPM0_b ) P_12_LLRVT l=6e-08 w=8e-07 ad=8e-14 as=8e-14 \
 pd=1e-06 ps=1e-06 nrd=0 nrs=0 sa=9.4e-07 sb=2.5e-06 sca=35.6769 scb=0.0251795 \
 scc=0.00354845
mXI4\/XI13\/MPM21 ( N_XI4\/XI13\/NET7_XI4\/XI13\/MPM21_d \
 N_XI4\/XI13\/NET35_XI4\/XI13\/MPM21_g N_XI4\/XI13\/NET015_XI4\/XI13\/MPM21_s \
 N_VDD_XI4\/XI18\/MPM0_b ) P_12_LLRVT l=6e-08 w=8e-07 ad=8e-14 as=8e-14 \
 pd=1e-06 ps=1e-06 nrd=0 nrs=0 sa=2.24e-06 sb=1.2e-06 sca=33.7574 \
 scb=0.0231451 scc=0.00354069
mXI4\/XI13\/MPM33 ( N_XI4\/XI13\/NET7_XI4\/XI13\/MPM33_d \
 N_XI4\/NET22_XI4\/XI13\/MPM33_g N_XI4\/XI13\/NET031_XI4\/XI13\/MPM33_s \
 N_VDD_XI4\/XI18\/MPM0_b ) P_12_LLRVT l=6e-08 w=8e-07 ad=8e-14 as=8e-14 \
 pd=1e-06 ps=1e-06 nrd=0 nrs=0 sa=2.5e-06 sb=9.4e-07 sca=33.9234 scb=0.0232171 \
 scc=0.00354071
mXI4\/XI14\/MPM16 ( N_XI4\/XI14\/NET35_XI4\/XI14\/MPM16_d \
 N_XI4\/NET24_XI4\/XI14\/MPM16_g N_XI4\/XI14\/NET06_XI4\/XI14\/MPM16_s \
 N_VDD_XI4\/XI18\/MPM0_b ) P_12_LLRVT l=6e-08 w=8e-07 ad=8e-14 as=8e-14 \
 pd=1e-06 ps=1e-06 nrd=0 nrs=0 sa=6.8e-07 sb=2.76e-06 sca=37.8517 \
 scb=0.0289498 scc=0.00362077
mXI4\/XI14\/MPM30 ( N_XI4\/XI14\/NET35_XI4\/XI14\/MPM30_d \
 N_A\<6\>_XI4\/XI14\/MPM30_g N_XI4\/XI14\/NET033_XI4\/XI14\/MPM30_s \
 N_VDD_XI4\/XI18\/MPM0_b ) P_12_LLRVT l=6e-08 w=8e-07 ad=8e-14 as=8e-14 \
 pd=1e-06 ps=1e-06 nrd=0 nrs=0 sa=9.4e-07 sb=2.5e-06 sca=35.6769 scb=0.0251795 \
 scc=0.00354845
mXI4\/XI14\/MPM21 ( N_XI4\/XI14\/NET7_XI4\/XI14\/MPM21_d \
 N_XI4\/XI14\/NET35_XI4\/XI14\/MPM21_g N_XI4\/XI14\/NET015_XI4\/XI14\/MPM21_s \
 N_VDD_XI4\/XI18\/MPM0_b ) P_12_LLRVT l=6e-08 w=8e-07 ad=8e-14 as=8e-14 \
 pd=1e-06 ps=1e-06 nrd=0 nrs=0 sa=2.24e-06 sb=1.2e-06 sca=33.7574 \
 scb=0.0231451 scc=0.00354069
mXI4\/XI14\/MPM33 ( N_XI4\/XI14\/NET7_XI4\/XI14\/MPM33_d \
 N_XI4\/NET24_XI4\/XI14\/MPM33_g N_XI4\/XI14\/NET031_XI4\/XI14\/MPM33_s \
 N_VDD_XI4\/XI18\/MPM0_b ) P_12_LLRVT l=6e-08 w=8e-07 ad=8e-14 as=8e-14 \
 pd=1e-06 ps=1e-06 nrd=0 nrs=0 sa=2.5e-06 sb=9.4e-07 sca=33.9234 scb=0.0232171 \
 scc=0.00354071
mXI4\/XI19\/MPM16 ( N_XI4\/XI19\/NET248_XI4\/XI19\/MPM16_d \
 N_XI4\/NET26_XI4\/XI19\/MPM16_g N_XI4\/XI19\/NET247_XI4\/XI19\/MPM16_s \
 N_VDD_XI4\/XI18\/MPM0_b ) P_12_LLRVT l=6e-08 w=8e-07 ad=8e-14 as=8e-14 \
 pd=1e-06 ps=1e-06 nrd=0 nrs=0 sa=6.8e-07 sb=2.76e-06 sca=37.8517 \
 scb=0.0289498 scc=0.00362077
mXI4\/XI19\/MPM30 ( N_XI4\/XI19\/NET248_XI4\/XI19\/MPM30_d \
 N_A\<7\>_XI4\/XI19\/MPM30_g N_XI4\/XI19\/NET259_XI4\/XI19\/MPM30_s \
 N_VDD_XI4\/XI18\/MPM0_b ) P_12_LLRVT l=6e-08 w=8e-07 ad=8e-14 as=8e-14 \
 pd=1e-06 ps=1e-06 nrd=0 nrs=0 sa=9.4e-07 sb=2.5e-06 sca=35.6769 scb=0.0251795 \
 scc=0.00354845
mXI4\/XI19\/MPM21 ( N_XI4\/XI19\/NET255_XI4\/XI19\/MPM21_d \
 N_XI4\/XI19\/NET248_XI4\/XI19\/MPM21_g N_XI4\/XI19\/NET253_XI4\/XI19\/MPM21_s \
 N_VDD_XI4\/XI18\/MPM0_b ) P_12_LLRVT l=6e-08 w=8e-07 ad=8e-14 as=8e-14 \
 pd=1e-06 ps=1e-06 nrd=0 nrs=0 sa=2.24e-06 sb=1.2e-06 sca=33.7574 \
 scb=0.0231451 scc=0.00354069
mXI4\/XI19\/MPM33 ( N_XI4\/XI19\/NET255_XI4\/XI19\/MPM33_d \
 N_XI4\/NET26_XI4\/XI19\/MPM33_g N_XI4\/XI19\/NET258_XI4\/XI19\/MPM33_s \
 N_VDD_XI4\/XI18\/MPM0_b ) P_12_LLRVT l=6e-08 w=8e-07 ad=8e-14 as=8e-14 \
 pd=1e-06 ps=1e-06 nrd=0 nrs=0 sa=2.5e-06 sb=9.4e-07 sca=33.9234 scb=0.0232171 \
 scc=0.00354071
mXI3\/XMUX\<0\>\/MPM1 ( N_XI3\/XMUX\<0\>\/NET17_XI3\/XMUX\<0\>\/MPM1_d \
 N_SEL_XI3\/XMUX\<0\>\/MPM1_g N_XI3\/XMUX\<0\>\/NET021_XI3\/XMUX\<0\>\/MPM1_s \
 N_VDD_XI0\/XLOGIC\<0\>\/MPM0_b ) P_12_LLRVT l=6e-08 w=4e-07 ad=4e-14 as=4e-14 \
 pd=6e-07 ps=6e-07 nrd=0 nrs=0 sa=6.8e-07 sb=9.4e-07 sca=27.021 scb=0.0283731 \
 scc=0.00289506
mXI3\/XMUX\<0\>\/MPM22 ( N_XI3\/XMUX\<0\>\/NET17_XI3\/XMUX\<0\>\/MPM22_d \
 N_XI3\/XMUX\<0\>\/S_INV_XI3\/XMUX\<0\>\/MPM22_g \
 N_XI3\/XMUX\<0\>\/NET025_XI3\/XMUX\<0\>\/MPM22_s \
 N_VDD_XI0\/XLOGIC\<0\>\/MPM0_b ) P_12_LLRVT l=6e-08 w=4e-07 ad=4e-14 as=4e-14 \
 pd=6e-07 ps=6e-07 nrd=0 nrs=0 sa=9.4e-07 sb=6.8e-07 sca=26.9576 scb=0.0283729 \
 scc=0.00289506
mXI3\/XMUX\<0\>\/MPM8 ( N_O\<0\>_XI3\/XMUX\<0\>\/MPM8_d \
 N_XI3\/XMUX\<0\>\/NET17_XI3\/XMUX\<0\>\/MPM8_g N_VDD_XI3\/XMUX\<0\>\/MPM8_s \
 N_VDD_XI0\/XLOGIC\<0\>\/MPM0_b ) P_12_LLRVT l=6e-08 w=4e-07 ad=6.4e-14 \
 as=4e-14 pd=1.12e-06 ps=6e-07 nrd=0 nrs=0 sa=1.46e-06 sb=1.6e-07 sca=26.8671 \
 scb=0.0283728 scc=0.00289506
mXI3\/XMUX\<0\>\/MPM0 ( N_XI3\/XMUX\<0\>\/S_INV_XI3\/XMUX\<0\>\/MPM0_d \
 N_SEL_XI3\/XMUX\<0\>\/MPM0_g N_VDD_XI3\/XMUX\<0\>\/MPM0_s \
 N_VDD_XI0\/XLOGIC\<0\>\/MPM0_b ) P_12_LLRVT l=6e-08 w=4e-07 ad=6.4e-14 \
 as=4e-14 pd=1.12e-06 ps=6e-07 nrd=0 nrs=0 sa=1.6e-07 sb=1.46e-06 sca=27.2108 \
 scb=0.0283765 scc=0.00289506
mXI3\/XMUX\<0\>\/MPM21 ( N_XI3\/XMUX\<0\>\/NET025_XI3\/XMUX\<0\>\/MPM21_d \
 N_S\<0\>_XI3\/XMUX\<0\>\/MPM21_g N_VDD_XI3\/XMUX\<0\>\/MPM21_s \
 N_VDD_XI0\/XLOGIC\<0\>\/MPM0_b ) P_12_LLRVT l=6e-08 w=4e-07 ad=4e-14 as=4e-14 \
 pd=6e-07 ps=6e-07 nrd=0 nrs=0 sa=1.2e-06 sb=4.2e-07 sca=26.9075 scb=0.0283729 \
 scc=0.00289506
mXI3\/XMUX\<0\>\/MPM6 ( N_XI3\/XMUX\<0\>\/NET021_XI3\/XMUX\<0\>\/MPM6_d \
 N_X\<0\>_XI3\/XMUX\<0\>\/MPM6_g N_VDD_XI3\/XMUX\<0\>\/MPM6_s \
 N_VDD_XI0\/XLOGIC\<0\>\/MPM0_b ) P_12_LLRVT l=6e-08 w=4e-07 ad=4e-14 as=4e-14 \
 pd=6e-07 ps=6e-07 nrd=0 nrs=0 sa=4.2e-07 sb=1.2e-06 sca=27.1028 scb=0.0283739 \
 scc=0.00289506
mXI3\/XMUX\<1\>\/MPM1 ( N_XI3\/XMUX\<1\>\/NET17_XI3\/XMUX\<1\>\/MPM1_d \
 N_SEL_XI3\/XMUX\<1\>\/MPM1_g N_XI3\/XMUX\<1\>\/NET021_XI3\/XMUX\<1\>\/MPM1_s \
 N_VDD_XI0\/XLOGIC\<0\>\/MPM0_b ) P_12_LLRVT l=6e-08 w=4e-07 ad=4e-14 as=4e-14 \
 pd=6e-07 ps=6e-07 nrd=0 nrs=0 sa=6.8e-07 sb=9.4e-07 sca=26.6539 scb=0.0283728 \
 scc=0.00289506
mXI3\/XMUX\<1\>\/MPM22 ( N_XI3\/XMUX\<1\>\/NET17_XI3\/XMUX\<1\>\/MPM22_d \
 N_XI3\/XMUX\<1\>\/S_INV_XI3\/XMUX\<1\>\/MPM22_g \
 N_XI3\/XMUX\<1\>\/NET025_XI3\/XMUX\<1\>\/MPM22_s \
 N_VDD_XI0\/XLOGIC\<0\>\/MPM0_b ) P_12_LLRVT l=6e-08 w=4e-07 ad=4e-14 as=4e-14 \
 pd=6e-07 ps=6e-07 nrd=0 nrs=0 sa=9.4e-07 sb=6.8e-07 sca=26.6506 scb=0.0283728 \
 scc=0.00289506
mXI3\/XMUX\<1\>\/MPM8 ( N_O\<1\>_XI3\/XMUX\<1\>\/MPM8_d \
 N_XI3\/XMUX\<1\>\/NET17_XI3\/XMUX\<1\>\/MPM8_g N_VDD_XI3\/XMUX\<1\>\/MPM8_s \
 N_VDD_XI0\/XLOGIC\<0\>\/MPM0_b ) P_12_LLRVT l=6e-08 w=4e-07 ad=6.4e-14 \
 as=4e-14 pd=1.12e-06 ps=6e-07 nrd=0 nrs=0 sa=1.46e-06 sb=1.6e-07 sca=26.6449 \
 scb=0.0283728 scc=0.00289506
mXI3\/XMUX\<1\>\/MPM0 ( N_XI3\/XMUX\<1\>\/S_INV_XI3\/XMUX\<1\>\/MPM0_d \
 N_SEL_XI3\/XMUX\<1\>\/MPM0_g N_VDD_XI3\/XMUX\<1\>\/MPM0_s \
 N_VDD_XI0\/XLOGIC\<0\>\/MPM0_b ) P_12_LLRVT l=6e-08 w=4e-07 ad=6.4e-14 \
 as=4e-14 pd=1.12e-06 ps=6e-07 nrd=0 nrs=0 sa=1.6e-07 sb=1.46e-06 sca=26.6615 \
 scb=0.0283728 scc=0.00289506
mXI3\/XMUX\<1\>\/MPM21 ( N_XI3\/XMUX\<1\>\/NET025_XI3\/XMUX\<1\>\/MPM21_d \
 N_S\<1\>_XI3\/XMUX\<1\>\/MPM21_g N_VDD_XI3\/XMUX\<1\>\/MPM21_s \
 N_VDD_XI0\/XLOGIC\<0\>\/MPM0_b ) P_12_LLRVT l=6e-08 w=4e-07 ad=4e-14 as=4e-14 \
 pd=6e-07 ps=6e-07 nrd=0 nrs=0 sa=1.2e-06 sb=4.2e-07 sca=26.6476 scb=0.0283728 \
 scc=0.00289506
mXI3\/XMUX\<1\>\/MPM6 ( N_XI3\/XMUX\<1\>\/NET021_XI3\/XMUX\<1\>\/MPM6_d \
 N_X\<1\>_XI3\/XMUX\<1\>\/MPM6_g N_VDD_XI3\/XMUX\<1\>\/MPM6_s \
 N_VDD_XI0\/XLOGIC\<0\>\/MPM0_b ) P_12_LLRVT l=6e-08 w=4e-07 ad=4e-14 as=4e-14 \
 pd=6e-07 ps=6e-07 nrd=0 nrs=0 sa=4.2e-07 sb=1.2e-06 sca=26.6575 scb=0.0283728 \
 scc=0.00289506
mXI3\/XMUX\<2\>\/MPM1 ( N_XI3\/XMUX\<2\>\/NET17_XI3\/XMUX\<2\>\/MPM1_d \
 N_SEL_XI3\/XMUX\<2\>\/MPM1_g N_XI3\/XMUX\<2\>\/NET021_XI3\/XMUX\<2\>\/MPM1_s \
 N_VDD_XI0\/XLOGIC\<0\>\/MPM0_b ) P_12_LLRVT l=6e-08 w=4e-07 ad=4e-14 as=4e-14 \
 pd=6e-07 ps=6e-07 nrd=0 nrs=0 sa=6.8e-07 sb=9.4e-07 sca=26.6189 scb=0.0283728 \
 scc=0.00289506
mXI3\/XMUX\<2\>\/MPM22 ( N_XI3\/XMUX\<2\>\/NET17_XI3\/XMUX\<2\>\/MPM22_d \
 N_XI3\/XMUX\<2\>\/S_INV_XI3\/XMUX\<2\>\/MPM22_g \
 N_XI3\/XMUX\<2\>\/NET025_XI3\/XMUX\<2\>\/MPM22_s \
 N_VDD_XI0\/XLOGIC\<0\>\/MPM0_b ) P_12_LLRVT l=6e-08 w=4e-07 ad=4e-14 as=4e-14 \
 pd=6e-07 ps=6e-07 nrd=0 nrs=0 sa=9.4e-07 sb=6.8e-07 sca=26.6181 scb=0.0283728 \
 scc=0.00289506
mXI3\/XMUX\<2\>\/MPM8 ( N_O\<2\>_XI3\/XMUX\<2\>\/MPM8_d \
 N_XI3\/XMUX\<2\>\/NET17_XI3\/XMUX\<2\>\/MPM8_g N_VDD_XI3\/XMUX\<2\>\/MPM8_s \
 N_VDD_XI0\/XLOGIC\<0\>\/MPM0_b ) P_12_LLRVT l=6e-08 w=4e-07 ad=6.4e-14 \
 as=4e-14 pd=1.12e-06 ps=6e-07 nrd=0 nrs=0 sa=1.46e-06 sb=1.6e-07 sca=26.6167 \
 scb=0.0283728 scc=0.00289506
mXI3\/XMUX\<2\>\/MPM0 ( N_XI3\/XMUX\<2\>\/S_INV_XI3\/XMUX\<2\>\/MPM0_d \
 N_SEL_XI3\/XMUX\<2\>\/MPM0_g N_VDD_XI3\/XMUX\<2\>\/MPM0_s \
 N_VDD_XI0\/XLOGIC\<0\>\/MPM0_b ) P_12_LLRVT l=6e-08 w=4e-07 ad=6.4e-14 \
 as=4e-14 pd=1.12e-06 ps=6e-07 nrd=0 nrs=0 sa=1.6e-07 sb=1.46e-06 sca=26.6205 \
 scb=0.0283728 scc=0.00289506
mXI3\/XMUX\<2\>\/MPM21 ( N_XI3\/XMUX\<2\>\/NET025_XI3\/XMUX\<2\>\/MPM21_d \
 N_S\<2\>_XI3\/XMUX\<2\>\/MPM21_g N_VDD_XI3\/XMUX\<2\>\/MPM21_s \
 N_VDD_XI0\/XLOGIC\<0\>\/MPM0_b ) P_12_LLRVT l=6e-08 w=4e-07 ad=4e-14 as=4e-14 \
 pd=6e-07 ps=6e-07 nrd=0 nrs=0 sa=1.2e-06 sb=4.2e-07 sca=26.6174 scb=0.0283728 \
 scc=0.00289506
mXI3\/XMUX\<2\>\/MPM6 ( N_XI3\/XMUX\<2\>\/NET021_XI3\/XMUX\<2\>\/MPM6_d \
 N_X\<2\>_XI3\/XMUX\<2\>\/MPM6_g N_VDD_XI3\/XMUX\<2\>\/MPM6_s \
 N_VDD_XI0\/XLOGIC\<0\>\/MPM0_b ) P_12_LLRVT l=6e-08 w=4e-07 ad=4e-14 as=4e-14 \
 pd=6e-07 ps=6e-07 nrd=0 nrs=0 sa=4.2e-07 sb=1.2e-06 sca=26.6197 scb=0.0283728 \
 scc=0.00289506
mXI3\/XMUX\<3\>\/MPM1 ( N_XI3\/XMUX\<3\>\/NET17_XI3\/XMUX\<3\>\/MPM1_d \
 N_SEL_XI3\/XMUX\<3\>\/MPM1_g N_XI3\/XMUX\<3\>\/NET021_XI3\/XMUX\<3\>\/MPM1_s \
 N_VDD_XI0\/XLOGIC\<0\>\/MPM0_b ) P_12_LLRVT l=6e-08 w=4e-07 ad=4e-14 as=4e-14 \
 pd=6e-07 ps=6e-07 nrd=0 nrs=0 sa=6.8e-07 sb=9.4e-07 sca=26.6088 scb=0.0283728 \
 scc=0.00289506
mXI3\/XMUX\<3\>\/MPM22 ( N_XI3\/XMUX\<3\>\/NET17_XI3\/XMUX\<3\>\/MPM22_d \
 N_XI3\/XMUX\<3\>\/S_INV_XI3\/XMUX\<3\>\/MPM22_g \
 N_XI3\/XMUX\<3\>\/NET025_XI3\/XMUX\<3\>\/MPM22_s \
 N_VDD_XI0\/XLOGIC\<0\>\/MPM0_b ) P_12_LLRVT l=6e-08 w=4e-07 ad=4e-14 as=4e-14 \
 pd=6e-07 ps=6e-07 nrd=0 nrs=0 sa=9.4e-07 sb=6.8e-07 sca=26.6085 scb=0.0283728 \
 scc=0.00289506
mXI3\/XMUX\<3\>\/MPM8 ( N_O\<3\>_XI3\/XMUX\<3\>\/MPM8_d \
 N_XI3\/XMUX\<3\>\/NET17_XI3\/XMUX\<3\>\/MPM8_g N_VDD_XI3\/XMUX\<3\>\/MPM8_s \
 N_VDD_XI0\/XLOGIC\<0\>\/MPM0_b ) P_12_LLRVT l=6e-08 w=4e-07 ad=6.4e-14 \
 as=4e-14 pd=1.12e-06 ps=6e-07 nrd=0 nrs=0 sa=1.46e-06 sb=1.6e-07 sca=26.608 \
 scb=0.0283728 scc=0.00289506
mXI3\/XMUX\<3\>\/MPM0 ( N_XI3\/XMUX\<3\>\/S_INV_XI3\/XMUX\<3\>\/MPM0_d \
 N_SEL_XI3\/XMUX\<3\>\/MPM0_g N_VDD_XI3\/XMUX\<3\>\/MPM0_s \
 N_VDD_XI0\/XLOGIC\<0\>\/MPM0_b ) P_12_LLRVT l=6e-08 w=4e-07 ad=6.4e-14 \
 as=4e-14 pd=1.12e-06 ps=6e-07 nrd=0 nrs=0 sa=1.6e-07 sb=1.46e-06 sca=26.6094 \
 scb=0.0283728 scc=0.00289506
mXI3\/XMUX\<3\>\/MPM21 ( N_XI3\/XMUX\<3\>\/NET025_XI3\/XMUX\<3\>\/MPM21_d \
 N_S\<3\>_XI3\/XMUX\<3\>\/MPM21_g N_VDD_XI3\/XMUX\<3\>\/MPM21_s \
 N_VDD_XI0\/XLOGIC\<0\>\/MPM0_b ) P_12_LLRVT l=6e-08 w=4e-07 ad=4e-14 as=4e-14 \
 pd=6e-07 ps=6e-07 nrd=0 nrs=0 sa=1.2e-06 sb=4.2e-07 sca=26.6082 scb=0.0283728 \
 scc=0.00289506
mXI3\/XMUX\<3\>\/MPM6 ( N_XI3\/XMUX\<3\>\/NET021_XI3\/XMUX\<3\>\/MPM6_d \
 N_X\<3\>_XI3\/XMUX\<3\>\/MPM6_g N_VDD_XI3\/XMUX\<3\>\/MPM6_s \
 N_VDD_XI0\/XLOGIC\<0\>\/MPM0_b ) P_12_LLRVT l=6e-08 w=4e-07 ad=4e-14 as=4e-14 \
 pd=6e-07 ps=6e-07 nrd=0 nrs=0 sa=4.2e-07 sb=1.2e-06 sca=26.6091 scb=0.0283728 \
 scc=0.00289506
mXI3\/XMUX\<4\>\/MPM1 ( N_XI3\/XMUX\<4\>\/NET17_XI3\/XMUX\<4\>\/MPM1_d \
 N_SEL_XI3\/XMUX\<4\>\/MPM1_g N_XI3\/XMUX\<4\>\/NET021_XI3\/XMUX\<4\>\/MPM1_s \
 N_VDD_XI0\/XLOGIC\<0\>\/MPM0_b ) P_12_LLRVT l=6e-08 w=4e-07 ad=4e-14 as=4e-14 \
 pd=6e-07 ps=6e-07 nrd=0 nrs=0 sa=6.8e-07 sb=9.4e-07 sca=26.6107 scb=0.0283728 \
 scc=0.00289506
mXI3\/XMUX\<4\>\/MPM22 ( N_XI3\/XMUX\<4\>\/NET17_XI3\/XMUX\<4\>\/MPM22_d \
 N_XI3\/XMUX\<4\>\/S_INV_XI3\/XMUX\<4\>\/MPM22_g \
 N_XI3\/XMUX\<4\>\/NET025_XI3\/XMUX\<4\>\/MPM22_s \
 N_VDD_XI0\/XLOGIC\<0\>\/MPM0_b ) P_12_LLRVT l=6e-08 w=4e-07 ad=4e-14 as=4e-14 \
 pd=6e-07 ps=6e-07 nrd=0 nrs=0 sa=9.4e-07 sb=6.8e-07 sca=26.6111 scb=0.0283728 \
 scc=0.00289506
mXI3\/XMUX\<4\>\/MPM8 ( N_O\<4\>_XI3\/XMUX\<4\>\/MPM8_d \
 N_XI3\/XMUX\<4\>\/NET17_XI3\/XMUX\<4\>\/MPM8_g N_VDD_XI3\/XMUX\<4\>\/MPM8_s \
 N_VDD_XI0\/XLOGIC\<0\>\/MPM0_b ) P_12_LLRVT l=6e-08 w=4e-07 ad=6.4e-14 \
 as=4e-14 pd=1.12e-06 ps=6e-07 nrd=0 nrs=0 sa=1.46e-06 sb=1.6e-07 sca=26.6119 \
 scb=0.0283728 scc=0.00289506
mXI3\/XMUX\<4\>\/MPM0 ( N_XI3\/XMUX\<4\>\/S_INV_XI3\/XMUX\<4\>\/MPM0_d \
 N_SEL_XI3\/XMUX\<4\>\/MPM0_g N_VDD_XI3\/XMUX\<4\>\/MPM0_s \
 N_VDD_XI0\/XLOGIC\<0\>\/MPM0_b ) P_12_LLRVT l=6e-08 w=4e-07 ad=6.4e-14 \
 as=4e-14 pd=1.12e-06 ps=6e-07 nrd=0 nrs=0 sa=1.6e-07 sb=1.46e-06 sca=26.61 \
 scb=0.0283728 scc=0.00289506
mXI3\/XMUX\<4\>\/MPM21 ( N_XI3\/XMUX\<4\>\/NET025_XI3\/XMUX\<4\>\/MPM21_d \
 N_S\<4\>_XI3\/XMUX\<4\>\/MPM21_g N_VDD_XI3\/XMUX\<4\>\/MPM21_s \
 N_VDD_XI0\/XLOGIC\<0\>\/MPM0_b ) P_12_LLRVT l=6e-08 w=4e-07 ad=4e-14 as=4e-14 \
 pd=6e-07 ps=6e-07 nrd=0 nrs=0 sa=1.2e-06 sb=4.2e-07 sca=26.6115 scb=0.0283728 \
 scc=0.00289506
mXI3\/XMUX\<4\>\/MPM6 ( N_XI3\/XMUX\<4\>\/NET021_XI3\/XMUX\<4\>\/MPM6_d \
 N_X\<4\>_XI3\/XMUX\<4\>\/MPM6_g N_VDD_XI3\/XMUX\<4\>\/MPM6_s \
 N_VDD_XI0\/XLOGIC\<0\>\/MPM0_b ) P_12_LLRVT l=6e-08 w=4e-07 ad=4e-14 as=4e-14 \
 pd=6e-07 ps=6e-07 nrd=0 nrs=0 sa=4.2e-07 sb=1.2e-06 sca=26.6103 scb=0.0283728 \
 scc=0.00289506
mXI3\/XMUX\<5\>\/MPM1 ( N_XI3\/XMUX\<5\>\/NET17_XI3\/XMUX\<5\>\/MPM1_d \
 N_SEL_XI3\/XMUX\<5\>\/MPM1_g N_XI3\/XMUX\<5\>\/NET021_XI3\/XMUX\<5\>\/MPM1_s \
 N_VDD_XI0\/XLOGIC\<0\>\/MPM0_b ) P_12_LLRVT l=6e-08 w=4e-07 ad=4e-14 as=4e-14 \
 pd=6e-07 ps=6e-07 nrd=0 nrs=0 sa=6.8e-07 sb=9.4e-07 sca=26.6243 scb=0.0283728 \
 scc=0.00289506
mXI3\/XMUX\<5\>\/MPM22 ( N_XI3\/XMUX\<5\>\/NET17_XI3\/XMUX\<5\>\/MPM22_d \
 N_XI3\/XMUX\<5\>\/S_INV_XI3\/XMUX\<5\>\/MPM22_g \
 N_XI3\/XMUX\<5\>\/NET025_XI3\/XMUX\<5\>\/MPM22_s \
 N_VDD_XI0\/XLOGIC\<0\>\/MPM0_b ) P_12_LLRVT l=6e-08 w=4e-07 ad=4e-14 as=4e-14 \
 pd=6e-07 ps=6e-07 nrd=0 nrs=0 sa=9.4e-07 sb=6.8e-07 sca=26.6254 scb=0.0283728 \
 scc=0.00289506
mXI3\/XMUX\<5\>\/MPM8 ( N_O\<5\>_XI3\/XMUX\<5\>\/MPM8_d \
 N_XI3\/XMUX\<5\>\/NET17_XI3\/XMUX\<5\>\/MPM8_g N_VDD_XI3\/XMUX\<5\>\/MPM8_s \
 N_VDD_XI0\/XLOGIC\<0\>\/MPM0_b ) P_12_LLRVT l=6e-08 w=4e-07 ad=6.4e-14 \
 as=4e-14 pd=1.12e-06 ps=6e-07 nrd=0 nrs=0 sa=1.46e-06 sb=1.6e-07 sca=26.628 \
 scb=0.0283728 scc=0.00289506
mXI3\/XMUX\<5\>\/MPM0 ( N_XI3\/XMUX\<5\>\/S_INV_XI3\/XMUX\<5\>\/MPM0_d \
 N_SEL_XI3\/XMUX\<5\>\/MPM0_g N_VDD_XI3\/XMUX\<5\>\/MPM0_s \
 N_VDD_XI0\/XLOGIC\<0\>\/MPM0_b ) P_12_LLRVT l=6e-08 w=4e-07 ad=6.4e-14 \
 as=4e-14 pd=1.12e-06 ps=6e-07 nrd=0 nrs=0 sa=1.6e-07 sb=1.46e-06 sca=26.6222 \
 scb=0.0283728 scc=0.00289506
mXI3\/XMUX\<5\>\/MPM21 ( N_XI3\/XMUX\<5\>\/NET025_XI3\/XMUX\<5\>\/MPM21_d \
 N_S\<5\>_XI3\/XMUX\<5\>\/MPM21_g N_VDD_XI3\/XMUX\<5\>\/MPM21_s \
 N_VDD_XI0\/XLOGIC\<0\>\/MPM0_b ) P_12_LLRVT l=6e-08 w=4e-07 ad=4e-14 as=4e-14 \
 pd=6e-07 ps=6e-07 nrd=0 nrs=0 sa=1.2e-06 sb=4.2e-07 sca=26.6267 scb=0.0283728 \
 scc=0.00289506
mXI3\/XMUX\<5\>\/MPM6 ( N_XI3\/XMUX\<5\>\/NET021_XI3\/XMUX\<5\>\/MPM6_d \
 N_X\<5\>_XI3\/XMUX\<5\>\/MPM6_g N_VDD_XI3\/XMUX\<5\>\/MPM6_s \
 N_VDD_XI0\/XLOGIC\<0\>\/MPM0_b ) P_12_LLRVT l=6e-08 w=4e-07 ad=4e-14 as=4e-14 \
 pd=6e-07 ps=6e-07 nrd=0 nrs=0 sa=4.2e-07 sb=1.2e-06 sca=26.6232 scb=0.0283728 \
 scc=0.00289506
mXI3\/XMUX\<6\>\/MPM1 ( N_XI3\/XMUX\<6\>\/NET17_XI3\/XMUX\<6\>\/MPM1_d \
 N_SEL_XI3\/XMUX\<6\>\/MPM1_g N_XI3\/XMUX\<6\>\/NET021_XI3\/XMUX\<6\>\/MPM1_s \
 N_VDD_XI0\/XLOGIC\<0\>\/MPM0_b ) P_12_LLRVT l=6e-08 w=4e-07 ad=4e-14 as=4e-14 \
 pd=6e-07 ps=6e-07 nrd=0 nrs=0 sa=6.8e-07 sb=9.4e-07 sca=26.6804 scb=0.0283728 \
 scc=0.00289506
mXI3\/XMUX\<6\>\/MPM22 ( N_XI3\/XMUX\<6\>\/NET17_XI3\/XMUX\<6\>\/MPM22_d \
 N_XI3\/XMUX\<6\>\/S_INV_XI3\/XMUX\<6\>\/MPM22_g \
 N_XI3\/XMUX\<6\>\/NET025_XI3\/XMUX\<6\>\/MPM22_s \
 N_VDD_XI0\/XLOGIC\<0\>\/MPM0_b ) P_12_LLRVT l=6e-08 w=4e-07 ad=4e-14 as=4e-14 \
 pd=6e-07 ps=6e-07 nrd=0 nrs=0 sa=9.4e-07 sb=6.8e-07 sca=26.6869 scb=0.0283728 \
 scc=0.00289506
mXI3\/XMUX\<6\>\/MPM8 ( N_O\<6\>_XI3\/XMUX\<6\>\/MPM8_d \
 N_XI3\/XMUX\<6\>\/NET17_XI3\/XMUX\<6\>\/MPM8_g N_VDD_XI3\/XMUX\<6\>\/MPM8_s \
 N_VDD_XI0\/XLOGIC\<0\>\/MPM0_b ) P_12_LLRVT l=6e-08 w=4e-07 ad=6.4e-14 \
 as=4e-14 pd=1.12e-06 ps=6e-07 nrd=0 nrs=0 sa=1.46e-06 sb=1.6e-07 sca=26.7025 \
 scb=0.0283728 scc=0.00289506
mXI3\/XMUX\<6\>\/MPM0 ( N_XI3\/XMUX\<6\>\/S_INV_XI3\/XMUX\<6\>\/MPM0_d \
 N_SEL_XI3\/XMUX\<6\>\/MPM0_g N_VDD_XI3\/XMUX\<6\>\/MPM0_s \
 N_VDD_XI0\/XLOGIC\<0\>\/MPM0_b ) P_12_LLRVT l=6e-08 w=4e-07 ad=6.4e-14 \
 as=4e-14 pd=1.12e-06 ps=6e-07 nrd=0 nrs=0 sa=1.6e-07 sb=1.46e-06 sca=26.6693 \
 scb=0.0283728 scc=0.00289506
mXI3\/XMUX\<6\>\/MPM21 ( N_XI3\/XMUX\<6\>\/NET025_XI3\/XMUX\<6\>\/MPM21_d \
 N_S\<6\>_XI3\/XMUX\<6\>\/MPM21_g N_VDD_XI3\/XMUX\<6\>\/MPM21_s \
 N_VDD_XI0\/XLOGIC\<0\>\/MPM0_b ) P_12_LLRVT l=6e-08 w=4e-07 ad=4e-14 as=4e-14 \
 pd=6e-07 ps=6e-07 nrd=0 nrs=0 sa=1.2e-06 sb=4.2e-07 sca=26.6943 scb=0.0283728 \
 scc=0.00289506
mXI3\/XMUX\<6\>\/MPM6 ( N_XI3\/XMUX\<6\>\/NET021_XI3\/XMUX\<6\>\/MPM6_d \
 N_X\<6\>_XI3\/XMUX\<6\>\/MPM6_g N_VDD_XI3\/XMUX\<6\>\/MPM6_s \
 N_VDD_XI0\/XLOGIC\<0\>\/MPM0_b ) P_12_LLRVT l=6e-08 w=4e-07 ad=4e-14 as=4e-14 \
 pd=6e-07 ps=6e-07 nrd=0 nrs=0 sa=4.2e-07 sb=1.2e-06 sca=26.6746 scb=0.0283728 \
 scc=0.00289506
mXI3\/XMUX\<7\>\/MPM1 ( N_XI3\/XMUX\<7\>\/NET17_XI3\/XMUX\<7\>\/MPM1_d \
 N_SEL_XI3\/XMUX\<7\>\/MPM1_g N_XI3\/XMUX\<7\>\/NET021_XI3\/XMUX\<7\>\/MPM1_s \
 N_VDD_XI0\/XLOGIC\<0\>\/MPM0_b ) P_12_LLRVT l=6e-08 w=4e-07 ad=4e-14 as=4e-14 \
 pd=6e-07 ps=6e-07 nrd=0 nrs=0 sa=6.8e-07 sb=9.4e-07 sca=28.104 scb=0.0286088 \
 scc=0.00289513
mXI3\/XMUX\<7\>\/MPM22 ( N_XI3\/XMUX\<7\>\/NET17_XI3\/XMUX\<7\>\/MPM22_d \
 N_XI3\/XMUX\<7\>\/S_INV_XI3\/XMUX\<7\>\/MPM22_g \
 N_XI3\/XMUX\<7\>\/NET025_XI3\/XMUX\<7\>\/MPM22_s \
 N_VDD_XI0\/XLOGIC\<0\>\/MPM0_b ) P_12_LLRVT l=6e-08 w=4e-07 ad=4e-14 as=4e-14 \
 pd=6e-07 ps=6e-07 nrd=0 nrs=0 sa=9.4e-07 sb=6.8e-07 sca=28.7301 scb=0.0291005 \
 scc=0.00289584
mXI3\/XMUX\<7\>\/MPM8 ( N_O\<7\>_XI3\/XMUX\<7\>\/MPM8_d \
 N_XI3\/XMUX\<7\>\/NET17_XI3\/XMUX\<7\>\/MPM8_g N_VDD_XI3\/XMUX\<7\>\/MPM8_s \
 N_VDD_XI0\/XLOGIC\<0\>\/MPM0_b ) P_12_LLRVT l=6e-08 w=4e-07 ad=6.4e-14 \
 as=4e-14 pd=1.12e-06 ps=6e-07 nrd=0 nrs=0 sa=1.46e-06 sb=1.6e-07 sca=32.1412 \
 scb=0.0344472 scc=0.00298253
mXI3\/XMUX\<7\>\/MPM0 ( N_XI3\/XMUX\<7\>\/S_INV_XI3\/XMUX\<7\>\/MPM0_d \
 N_SEL_XI3\/XMUX\<7\>\/MPM0_g N_VDD_XI3\/XMUX\<7\>\/MPM0_s \
 N_VDD_XI0\/XLOGIC\<0\>\/MPM0_b ) P_12_LLRVT l=6e-08 w=4e-07 ad=6.4e-14 \
 as=4e-14 pd=1.12e-06 ps=6e-07 nrd=0 nrs=0 sa=1.6e-07 sb=1.46e-06 sca=27.4635 \
 scb=0.0283959 scc=0.00289506
mXI3\/XMUX\<7\>\/MPM21 ( N_XI3\/XMUX\<7\>\/NET025_XI3\/XMUX\<7\>\/MPM21_d \
 N_S\<7\>_XI3\/XMUX\<7\>\/MPM21_g N_VDD_XI3\/XMUX\<7\>\/MPM21_s \
 N_VDD_XI0\/XLOGIC\<0\>\/MPM0_b ) P_12_LLRVT l=6e-08 w=4e-07 ad=4e-14 as=4e-14 \
 pd=6e-07 ps=6e-07 nrd=0 nrs=0 sa=1.2e-06 sb=4.2e-07 sca=29.8468 scb=0.0305355 \
 scc=0.00290355
mXI3\/XMUX\<7\>\/MPM6 ( N_XI3\/XMUX\<7\>\/NET021_XI3\/XMUX\<7\>\/MPM6_d \
 N_X\<7\>_XI3\/XMUX\<7\>\/MPM6_g N_VDD_XI3\/XMUX\<7\>\/MPM6_s \
 N_VDD_XI0\/XLOGIC\<0\>\/MPM0_b ) P_12_LLRVT l=6e-08 w=4e-07 ad=4e-14 as=4e-14 \
 pd=6e-07 ps=6e-07 nrd=0 nrs=0 sa=4.2e-07 sb=1.2e-06 sca=27.718 scb=0.0284474 \
 scc=0.00289507
mXI4\/XI18\/MPM29 ( N_XI4\/XI18\/NET259_XI4\/XI18\/MPM29_d \
 N_B\<0\>_XI4\/XI18\/MPM29_g N_VDD_XI4\/XI18\/MPM29_s N_VDD_XI4\/XI18\/MPM0_b \
 ) P_12_LLRVT l=6e-08 w=8e-07 ad=8e-14 as=8e-14 pd=1e-06 ps=1e-06 nrd=0 nrs=0 \
 sa=1.2e-06 sb=2.24e-06 sca=34.6492 scb=0.0238012 scc=0.0035414
mXI4\/XI9\/MPM24 ( N_XI4\/XI9\/NET015_XI4\/XI9\/MPM24_d \
 N_XI4\/NET12_XI4\/XI9\/MPM24_g N_VDD_XI4\/XI9\/MPM24_s \
 N_VDD_XI4\/XI18\/MPM0_b ) P_12_LLRVT l=6e-08 w=8e-07 ad=8e-14 as=8e-14 \
 pd=1e-06 ps=1e-06 nrd=0 nrs=0 sa=1.98e-06 sb=1.46e-06 sca=33.7323 \
 scb=0.0231364 scc=0.00354069
mXI4\/XI10\/MPM24 ( N_XI4\/XI10\/NET015_XI4\/XI10\/MPM24_d \
 N_XI4\/NET16_XI4\/XI10\/MPM24_g N_VDD_XI4\/XI10\/MPM24_s \
 N_VDD_XI4\/XI18\/MPM0_b ) P_12_LLRVT l=6e-08 w=8e-07 ad=8e-14 as=8e-14 \
 pd=1e-06 ps=1e-06 nrd=0 nrs=0 sa=1.98e-06 sb=1.46e-06 sca=33.7323 \
 scb=0.0231364 scc=0.00354069
mXI4\/XI11\/MPM24 ( N_XI4\/XI11\/NET015_XI4\/XI11\/MPM24_d \
 N_XI4\/NET18_XI4\/XI11\/MPM24_g N_VDD_XI4\/XI11\/MPM24_s \
 N_VDD_XI4\/XI18\/MPM0_b ) P_12_LLRVT l=6e-08 w=8e-07 ad=8e-14 as=8e-14 \
 pd=1e-06 ps=1e-06 nrd=0 nrs=0 sa=1.98e-06 sb=1.46e-06 sca=33.7323 \
 scb=0.0231364 scc=0.00354069
mXI4\/XI12\/MPM24 ( N_XI4\/XI12\/NET015_XI4\/XI12\/MPM24_d \
 N_XI4\/NET20_XI4\/XI12\/MPM24_g N_VDD_XI4\/XI12\/MPM24_s \
 N_VDD_XI4\/XI18\/MPM0_b ) P_12_LLRVT l=6e-08 w=8e-07 ad=8e-14 as=8e-14 \
 pd=1e-06 ps=1e-06 nrd=0 nrs=0 sa=1.98e-06 sb=1.46e-06 sca=33.7323 \
 scb=0.0231364 scc=0.00354069
mXI4\/XI13\/MPM24 ( N_XI4\/XI13\/NET015_XI4\/XI13\/MPM24_d \
 N_XI4\/NET22_XI4\/XI13\/MPM24_g N_VDD_XI4\/XI13\/MPM24_s \
 N_VDD_XI4\/XI18\/MPM0_b ) P_12_LLRVT l=6e-08 w=8e-07 ad=8e-14 as=8e-14 \
 pd=1e-06 ps=1e-06 nrd=0 nrs=0 sa=1.98e-06 sb=1.46e-06 sca=33.7323 \
 scb=0.0231364 scc=0.00354069
mXI4\/XI14\/MPM24 ( N_XI4\/XI14\/NET015_XI4\/XI14\/MPM24_d \
 N_XI4\/NET24_XI4\/XI14\/MPM24_g N_VDD_XI4\/XI14\/MPM24_s \
 N_VDD_XI4\/XI18\/MPM0_b ) P_12_LLRVT l=6e-08 w=8e-07 ad=8e-14 as=8e-14 \
 pd=1e-06 ps=1e-06 nrd=0 nrs=0 sa=1.98e-06 sb=1.46e-06 sca=33.7323 \
 scb=0.0231364 scc=0.00354069
mXI4\/XI19\/MPM24 ( N_XI4\/XI19\/NET253_XI4\/XI19\/MPM24_d \
 N_XI4\/NET26_XI4\/XI19\/MPM24_g N_VDD_XI4\/XI19\/MPM24_s \
 N_VDD_XI4\/XI18\/MPM0_b ) P_12_LLRVT l=6e-08 w=8e-07 ad=8e-14 as=8e-14 \
 pd=1e-06 ps=1e-06 nrd=0 nrs=0 sa=1.98e-06 sb=1.46e-06 sca=33.7323 \
 scb=0.0231364 scc=0.00354069
mXI0\/XLOGIC\<0\>\/MPM1 ( N_X\<0\>_XI0\/XLOGIC\<0\>\/MPM1_d \
 N_CTR\<1\>_XI0\/XLOGIC\<0\>\/MPM1_g \
 N_XI0\/XLOGIC\<0\>\/NET16_XI0\/XLOGIC\<0\>\/MPM1_s \
 N_VDD_XI0\/XLOGIC\<0\>\/MPM0_b ) P_12_LLRVT l=6e-08 w=4e-07 ad=4e-14 as=4e-14 \
 pd=6e-07 ps=6e-07 nrd=0 nrs=0 sa=4.2e-07 sb=9.4e-07 sca=37.7369 scb=0.0433276 \
 scc=0.00364614
mXI0\/XLOGIC\<0\>\/MPM17 ( N_X\<0\>_XI0\/XLOGIC\<0\>\/MPM17_d \
 N_A\<0\>_XI0\/XLOGIC\<0\>\/MPM17_g \
 N_XI0\/XLOGIC\<0\>\/NET011_XI0\/XLOGIC\<0\>\/MPM17_s \
 N_VDD_XI0\/XLOGIC\<0\>\/MPM0_b ) P_12_LLRVT l=6e-08 w=4e-07 ad=4e-14 as=4e-14 \
 pd=6e-07 ps=6e-07 nrd=0 nrs=0 sa=6.8e-07 sb=6.8e-07 sca=32.0129 scb=0.034219 \
 scc=0.00297514
mXI0\/XLOGIC\<0\>\/MPM15 ( \
 N_XI0\/XLOGIC\<0\>\/NET011_XI0\/XLOGIC\<0\>\/MPM15_d \
 N_B\<0\>_XI0\/XLOGIC\<0\>\/MPM15_g N_VDD_XI0\/XLOGIC\<0\>\/MPM15_s \
 N_VDD_XI0\/XLOGIC\<0\>\/MPM0_b ) P_12_LLRVT l=6e-08 w=4e-07 ad=6.4e-14 \
 as=4e-14 pd=1.12e-06 ps=6e-07 nrd=0 nrs=0 sa=1.2e-06 sb=1.6e-07 sca=28.6993 \
 scb=0.0290701 scc=0.00289577
mXI0\/XLOGIC\<0\>\/MPM16 ( \
 N_XI0\/XLOGIC\<0\>\/NET011_XI0\/XLOGIC\<0\>\/MPM16_d \
 N_CTR\<0\>_XI0\/XLOGIC\<0\>\/MPM16_g N_VDD_XI0\/XLOGIC\<0\>\/MPM16_s \
 N_VDD_XI0\/XLOGIC\<0\>\/MPM0_b ) P_12_LLRVT l=6e-08 w=4e-07 ad=4e-14 as=4e-14 \
 pd=6e-07 ps=6e-07 nrd=0 nrs=0 sa=9.4e-07 sb=4.2e-07 sca=29.789 scb=0.0304486 \
 scc=0.00290282
mXI0\/XLOGIC\<0\>\/MPM0 ( N_XI0\/XLOGIC\<0\>\/NET16_XI0\/XLOGIC\<0\>\/MPM0_d \
 N_B\<0\>_XI0\/XLOGIC\<0\>\/MPM0_g N_VDD_XI0\/XLOGIC\<0\>\/MPM0_s \
 N_VDD_XI0\/XLOGIC\<0\>\/MPM0_b ) P_12_LLRVT l=6e-08 w=4e-07 ad=4e-14 \
 as=6.4e-14 pd=6e-07 ps=1.12e-06 nrd=0 nrs=0 sa=1.6e-07 sb=1.2e-06 sca=61.4715 \
 scb=0.0594083 scc=0.00860349
mXI0\/XLOGIC\<1\>\/MPM1 ( N_X\<1\>_XI0\/XLOGIC\<1\>\/MPM1_d \
 N_CTR\<1\>_XI0\/XLOGIC\<1\>\/MPM1_g \
 N_XI0\/XLOGIC\<1\>\/NET16_XI0\/XLOGIC\<1\>\/MPM1_s \
 N_VDD_XI0\/XLOGIC\<0\>\/MPM0_b ) P_12_LLRVT l=6e-08 w=4e-07 ad=4e-14 as=4e-14 \
 pd=6e-07 ps=6e-07 nrd=0 nrs=0 sa=4.2e-07 sb=9.4e-07 sca=26.7098 scb=0.0283728 \
 scc=0.00289506
mXI0\/XLOGIC\<1\>\/MPM17 ( N_X\<1\>_XI0\/XLOGIC\<1\>\/MPM17_d \
 N_A\<1\>_XI0\/XLOGIC\<1\>\/MPM17_g \
 N_XI0\/XLOGIC\<1\>\/NET011_XI0\/XLOGIC\<1\>\/MPM17_s \
 N_VDD_XI0\/XLOGIC\<0\>\/MPM0_b ) P_12_LLRVT l=6e-08 w=4e-07 ad=4e-14 as=4e-14 \
 pd=6e-07 ps=6e-07 nrd=0 nrs=0 sa=6.8e-07 sb=6.8e-07 sca=26.7007 scb=0.0283728 \
 scc=0.00289506
mXI0\/XLOGIC\<1\>\/MPM15 ( \
 N_XI0\/XLOGIC\<1\>\/NET011_XI0\/XLOGIC\<1\>\/MPM15_d \
 N_B\<1\>_XI0\/XLOGIC\<1\>\/MPM15_g N_VDD_XI0\/XLOGIC\<1\>\/MPM15_s \
 N_VDD_XI0\/XLOGIC\<0\>\/MPM0_b ) P_12_LLRVT l=6e-08 w=4e-07 ad=6.4e-14 \
 as=4e-14 pd=1.12e-06 ps=6e-07 nrd=0 nrs=0 sa=1.2e-06 sb=1.6e-07 sca=26.6855 \
 scb=0.0283728 scc=0.00289506
mXI0\/XLOGIC\<1\>\/MPM16 ( \
 N_XI0\/XLOGIC\<1\>\/NET011_XI0\/XLOGIC\<1\>\/MPM16_d \
 N_CTR\<0\>_XI0\/XLOGIC\<1\>\/MPM16_g N_VDD_XI0\/XLOGIC\<1\>\/MPM16_s \
 N_VDD_XI0\/XLOGIC\<0\>\/MPM0_b ) P_12_LLRVT l=6e-08 w=4e-07 ad=4e-14 as=4e-14 \
 pd=6e-07 ps=6e-07 nrd=0 nrs=0 sa=9.4e-07 sb=4.2e-07 sca=26.6926 scb=0.0283728 \
 scc=0.00289506
mXI0\/XLOGIC\<1\>\/MPM0 ( N_XI0\/XLOGIC\<1\>\/NET16_XI0\/XLOGIC\<1\>\/MPM0_d \
 N_B\<1\>_XI0\/XLOGIC\<1\>\/MPM0_g N_VDD_XI0\/XLOGIC\<1\>\/MPM0_s \
 N_VDD_XI0\/XLOGIC\<0\>\/MPM0_b ) P_12_LLRVT l=6e-08 w=4e-07 ad=4e-14 \
 as=6.4e-14 pd=6e-07 ps=1.12e-06 nrd=0 nrs=0 sa=1.6e-07 sb=1.2e-06 sca=26.7202 \
 scb=0.0283728 scc=0.00289506
mXI0\/XLOGIC\<2\>\/MPM1 ( N_X\<2\>_XI0\/XLOGIC\<2\>\/MPM1_d \
 N_CTR\<1\>_XI0\/XLOGIC\<2\>\/MPM1_g \
 N_XI0\/XLOGIC\<2\>\/NET16_XI0\/XLOGIC\<2\>\/MPM1_s \
 N_VDD_XI0\/XLOGIC\<0\>\/MPM0_b ) P_12_LLRVT l=6e-08 w=4e-07 ad=4e-14 as=4e-14 \
 pd=6e-07 ps=6e-07 nrd=0 nrs=0 sa=4.2e-07 sb=9.4e-07 sca=26.6289 scb=0.0283728 \
 scc=0.00289506
mXI0\/XLOGIC\<2\>\/MPM17 ( N_X\<2\>_XI0\/XLOGIC\<2\>\/MPM17_d \
 N_A\<2\>_XI0\/XLOGIC\<2\>\/MPM17_g \
 N_XI0\/XLOGIC\<2\>\/NET011_XI0\/XLOGIC\<2\>\/MPM17_s \
 N_VDD_XI0\/XLOGIC\<0\>\/MPM0_b ) P_12_LLRVT l=6e-08 w=4e-07 ad=4e-14 as=4e-14 \
 pd=6e-07 ps=6e-07 nrd=0 nrs=0 sa=6.8e-07 sb=6.8e-07 sca=26.6276 scb=0.0283728 \
 scc=0.00289506
mXI0\/XLOGIC\<2\>\/MPM15 ( \
 N_XI0\/XLOGIC\<2\>\/NET011_XI0\/XLOGIC\<2\>\/MPM15_d \
 N_B\<2\>_XI0\/XLOGIC\<2\>\/MPM15_g N_VDD_XI0\/XLOGIC\<2\>\/MPM15_s \
 N_VDD_XI0\/XLOGIC\<0\>\/MPM0_b ) P_12_LLRVT l=6e-08 w=4e-07 ad=6.4e-14 \
 as=4e-14 pd=1.12e-06 ps=6e-07 nrd=0 nrs=0 sa=1.2e-06 sb=1.6e-07 sca=26.6251 \
 scb=0.0283728 scc=0.00289506
mXI0\/XLOGIC\<2\>\/MPM16 ( \
 N_XI0\/XLOGIC\<2\>\/NET011_XI0\/XLOGIC\<2\>\/MPM16_d \
 N_CTR\<0\>_XI0\/XLOGIC\<2\>\/MPM16_g N_VDD_XI0\/XLOGIC\<2\>\/MPM16_s \
 N_VDD_XI0\/XLOGIC\<0\>\/MPM0_b ) P_12_LLRVT l=6e-08 w=4e-07 ad=4e-14 as=4e-14 \
 pd=6e-07 ps=6e-07 nrd=0 nrs=0 sa=9.4e-07 sb=4.2e-07 sca=26.6263 scb=0.0283728 \
 scc=0.00289506
mXI0\/XLOGIC\<2\>\/MPM0 ( N_XI0\/XLOGIC\<2\>\/NET16_XI0\/XLOGIC\<2\>\/MPM0_d \
 N_B\<2\>_XI0\/XLOGIC\<2\>\/MPM0_g N_VDD_XI0\/XLOGIC\<2\>\/MPM0_s \
 N_VDD_XI0\/XLOGIC\<0\>\/MPM0_b ) P_12_LLRVT l=6e-08 w=4e-07 ad=4e-14 \
 as=6.4e-14 pd=6e-07 ps=1.12e-06 nrd=0 nrs=0 sa=1.6e-07 sb=1.2e-06 sca=26.6304 \
 scb=0.0283728 scc=0.00289506
mXI0\/XLOGIC\<3\>\/MPM1 ( N_X\<3\>_XI0\/XLOGIC\<3\>\/MPM1_d \
 N_CTR\<1\>_XI0\/XLOGIC\<3\>\/MPM1_g \
 N_XI0\/XLOGIC\<3\>\/NET16_XI0\/XLOGIC\<3\>\/MPM1_s \
 N_VDD_XI0\/XLOGIC\<0\>\/MPM0_b ) P_12_LLRVT l=6e-08 w=4e-07 ad=4e-14 as=4e-14 \
 pd=6e-07 ps=6e-07 nrd=0 nrs=0 sa=4.2e-07 sb=9.4e-07 sca=26.6122 scb=0.0283728 \
 scc=0.00289506
mXI0\/XLOGIC\<3\>\/MPM17 ( N_X\<3\>_XI0\/XLOGIC\<3\>\/MPM17_d \
 N_A\<3\>_XI0\/XLOGIC\<3\>\/MPM17_g \
 N_XI0\/XLOGIC\<3\>\/NET011_XI0\/XLOGIC\<3\>\/MPM17_s \
 N_VDD_XI0\/XLOGIC\<0\>\/MPM0_b ) P_12_LLRVT l=6e-08 w=4e-07 ad=4e-14 as=4e-14 \
 pd=6e-07 ps=6e-07 nrd=0 nrs=0 sa=6.8e-07 sb=6.8e-07 sca=26.6118 scb=0.0283728 \
 scc=0.00289506
mXI0\/XLOGIC\<3\>\/MPM15 ( \
 N_XI0\/XLOGIC\<3\>\/NET011_XI0\/XLOGIC\<3\>\/MPM15_d \
 N_B\<3\>_XI0\/XLOGIC\<3\>\/MPM15_g N_VDD_XI0\/XLOGIC\<3\>\/MPM15_s \
 N_VDD_XI0\/XLOGIC\<0\>\/MPM0_b ) P_12_LLRVT l=6e-08 w=4e-07 ad=6.4e-14 \
 as=4e-14 pd=1.12e-06 ps=6e-07 nrd=0 nrs=0 sa=1.2e-06 sb=1.6e-07 sca=26.611 \
 scb=0.0283728 scc=0.00289506
mXI0\/XLOGIC\<3\>\/MPM16 ( \
 N_XI0\/XLOGIC\<3\>\/NET011_XI0\/XLOGIC\<3\>\/MPM16_d \
 N_CTR\<0\>_XI0\/XLOGIC\<3\>\/MPM16_g N_VDD_XI0\/XLOGIC\<3\>\/MPM16_s \
 N_VDD_XI0\/XLOGIC\<0\>\/MPM0_b ) P_12_LLRVT l=6e-08 w=4e-07 ad=4e-14 as=4e-14 \
 pd=6e-07 ps=6e-07 nrd=0 nrs=0 sa=9.4e-07 sb=4.2e-07 sca=26.6114 scb=0.0283728 \
 scc=0.00289506
mXI0\/XLOGIC\<3\>\/MPM0 ( N_XI0\/XLOGIC\<3\>\/NET16_XI0\/XLOGIC\<3\>\/MPM0_d \
 N_B\<3\>_XI0\/XLOGIC\<3\>\/MPM0_g N_VDD_XI0\/XLOGIC\<3\>\/MPM0_s \
 N_VDD_XI0\/XLOGIC\<0\>\/MPM0_b ) P_12_LLRVT l=6e-08 w=4e-07 ad=4e-14 \
 as=6.4e-14 pd=6e-07 ps=1.12e-06 nrd=0 nrs=0 sa=1.6e-07 sb=1.2e-06 sca=26.6127 \
 scb=0.0283728 scc=0.00289506
mXI0\/XLOGIC\<4\>\/MPM1 ( N_X\<4\>_XI0\/XLOGIC\<4\>\/MPM1_d \
 N_CTR\<1\>_XI0\/XLOGIC\<4\>\/MPM1_g \
 N_XI0\/XLOGIC\<4\>\/NET16_XI0\/XLOGIC\<4\>\/MPM1_s \
 N_VDD_XI0\/XLOGIC\<0\>\/MPM0_b ) P_12_LLRVT l=6e-08 w=4e-07 ad=4e-14 as=4e-14 \
 pd=6e-07 ps=6e-07 nrd=0 nrs=0 sa=4.2e-07 sb=9.4e-07 sca=26.6079 scb=0.0283728 \
 scc=0.00289506
mXI0\/XLOGIC\<4\>\/MPM17 ( N_X\<4\>_XI0\/XLOGIC\<4\>\/MPM17_d \
 N_A\<4\>_XI0\/XLOGIC\<4\>\/MPM17_g \
 N_XI0\/XLOGIC\<4\>\/NET011_XI0\/XLOGIC\<4\>\/MPM17_s \
 N_VDD_XI0\/XLOGIC\<0\>\/MPM0_b ) P_12_LLRVT l=6e-08 w=4e-07 ad=4e-14 as=4e-14 \
 pd=6e-07 ps=6e-07 nrd=0 nrs=0 sa=6.8e-07 sb=6.8e-07 sca=26.608 scb=0.0283728 \
 scc=0.00289506
mXI0\/XLOGIC\<4\>\/MPM15 ( \
 N_XI0\/XLOGIC\<4\>\/NET011_XI0\/XLOGIC\<4\>\/MPM15_d \
 N_B\<4\>_XI0\/XLOGIC\<4\>\/MPM15_g N_VDD_XI0\/XLOGIC\<4\>\/MPM15_s \
 N_VDD_XI0\/XLOGIC\<0\>\/MPM0_b ) P_12_LLRVT l=6e-08 w=4e-07 ad=6.4e-14 \
 as=4e-14 pd=1.12e-06 ps=6e-07 nrd=0 nrs=0 sa=1.2e-06 sb=1.6e-07 sca=26.6086 \
 scb=0.0283728 scc=0.00289506
mXI0\/XLOGIC\<4\>\/MPM16 ( \
 N_XI0\/XLOGIC\<4\>\/NET011_XI0\/XLOGIC\<4\>\/MPM16_d \
 N_CTR\<0\>_XI0\/XLOGIC\<4\>\/MPM16_g N_VDD_XI0\/XLOGIC\<4\>\/MPM16_s \
 N_VDD_XI0\/XLOGIC\<0\>\/MPM0_b ) P_12_LLRVT l=6e-08 w=4e-07 ad=4e-14 as=4e-14 \
 pd=6e-07 ps=6e-07 nrd=0 nrs=0 sa=9.4e-07 sb=4.2e-07 sca=26.6083 scb=0.0283728 \
 scc=0.00289506
mXI0\/XLOGIC\<4\>\/MPM0 ( N_XI0\/XLOGIC\<4\>\/NET16_XI0\/XLOGIC\<4\>\/MPM0_d \
 N_B\<4\>_XI0\/XLOGIC\<4\>\/MPM0_g N_VDD_XI0\/XLOGIC\<4\>\/MPM0_s \
 N_VDD_XI0\/XLOGIC\<0\>\/MPM0_b ) P_12_LLRVT l=6e-08 w=4e-07 ad=4e-14 \
 as=6.4e-14 pd=6e-07 ps=1.12e-06 nrd=0 nrs=0 sa=1.6e-07 sb=1.2e-06 sca=26.6079 \
 scb=0.0283728 scc=0.00289506
mXI0\/XLOGIC\<5\>\/MPM1 ( N_X\<5\>_XI0\/XLOGIC\<5\>\/MPM1_d \
 N_CTR\<1\>_XI0\/XLOGIC\<5\>\/MPM1_g \
 N_XI0\/XLOGIC\<5\>\/NET16_XI0\/XLOGIC\<5\>\/MPM1_s \
 N_VDD_XI0\/XLOGIC\<0\>\/MPM0_b ) P_12_LLRVT l=6e-08 w=4e-07 ad=4e-14 as=4e-14 \
 pd=6e-07 ps=6e-07 nrd=0 nrs=0 sa=4.2e-07 sb=9.4e-07 sca=26.6162 scb=0.0283728 \
 scc=0.00289506
mXI0\/XLOGIC\<5\>\/MPM17 ( N_X\<5\>_XI0\/XLOGIC\<5\>\/MPM17_d \
 N_A\<5\>_XI0\/XLOGIC\<5\>\/MPM17_g \
 N_XI0\/XLOGIC\<5\>\/NET011_XI0\/XLOGIC\<5\>\/MPM17_s \
 N_VDD_XI0\/XLOGIC\<0\>\/MPM0_b ) P_12_LLRVT l=6e-08 w=4e-07 ad=4e-14 as=4e-14 \
 pd=6e-07 ps=6e-07 nrd=0 nrs=0 sa=6.8e-07 sb=6.8e-07 sca=26.6169 scb=0.0283728 \
 scc=0.00289506
mXI0\/XLOGIC\<5\>\/MPM15 ( \
 N_XI0\/XLOGIC\<5\>\/NET011_XI0\/XLOGIC\<5\>\/MPM15_d \
 N_B\<5\>_XI0\/XLOGIC\<5\>\/MPM15_g N_VDD_XI0\/XLOGIC\<5\>\/MPM15_s \
 N_VDD_XI0\/XLOGIC\<0\>\/MPM0_b ) P_12_LLRVT l=6e-08 w=4e-07 ad=6.4e-14 \
 as=4e-14 pd=1.12e-06 ps=6e-07 nrd=0 nrs=0 sa=1.2e-06 sb=1.6e-07 sca=26.6183 \
 scb=0.0283728 scc=0.00289506
mXI0\/XLOGIC\<5\>\/MPM16 ( \
 N_XI0\/XLOGIC\<5\>\/NET011_XI0\/XLOGIC\<5\>\/MPM16_d \
 N_CTR\<0\>_XI0\/XLOGIC\<5\>\/MPM16_g N_VDD_XI0\/XLOGIC\<5\>\/MPM16_s \
 N_VDD_XI0\/XLOGIC\<0\>\/MPM0_b ) P_12_LLRVT l=6e-08 w=4e-07 ad=4e-14 as=4e-14 \
 pd=6e-07 ps=6e-07 nrd=0 nrs=0 sa=9.4e-07 sb=4.2e-07 sca=26.6176 scb=0.0283728 \
 scc=0.00289506
mXI0\/XLOGIC\<5\>\/MPM0 ( N_XI0\/XLOGIC\<5\>\/NET16_XI0\/XLOGIC\<5\>\/MPM0_d \
 N_B\<5\>_XI0\/XLOGIC\<5\>\/MPM0_g N_VDD_XI0\/XLOGIC\<5\>\/MPM0_s \
 N_VDD_XI0\/XLOGIC\<0\>\/MPM0_b ) P_12_LLRVT l=6e-08 w=4e-07 ad=4e-14 \
 as=6.4e-14 pd=6e-07 ps=1.12e-06 nrd=0 nrs=0 sa=1.6e-07 sb=1.2e-06 sca=26.6156 \
 scb=0.0283728 scc=0.00289506
mXI0\/XLOGIC\<6\>\/MPM1 ( N_X\<6\>_XI0\/XLOGIC\<6\>\/MPM1_d \
 N_CTR\<1\>_XI0\/XLOGIC\<6\>\/MPM1_g \
 N_XI0\/XLOGIC\<6\>\/NET16_XI0\/XLOGIC\<6\>\/MPM1_s \
 N_VDD_XI0\/XLOGIC\<0\>\/MPM0_b ) P_12_LLRVT l=6e-08 w=4e-07 ad=4e-14 as=4e-14 \
 pd=6e-07 ps=6e-07 nrd=0 nrs=0 sa=4.2e-07 sb=9.4e-07 sca=26.643 scb=0.0283728 \
 scc=0.00289506
mXI0\/XLOGIC\<6\>\/MPM17 ( N_X\<6\>_XI0\/XLOGIC\<6\>\/MPM17_d \
 N_A\<6\>_XI0\/XLOGIC\<6\>\/MPM17_g \
 N_XI0\/XLOGIC\<6\>\/NET011_XI0\/XLOGIC\<6\>\/MPM17_s \
 N_VDD_XI0\/XLOGIC\<0\>\/MPM0_b ) P_12_LLRVT l=6e-08 w=4e-07 ad=4e-14 as=4e-14 \
 pd=6e-07 ps=6e-07 nrd=0 nrs=0 sa=6.8e-07 sb=6.8e-07 sca=26.6456 scb=0.0283728 \
 scc=0.00289506
mXI0\/XLOGIC\<6\>\/MPM15 ( \
 N_XI0\/XLOGIC\<6\>\/NET011_XI0\/XLOGIC\<6\>\/MPM15_d \
 N_B\<6\>_XI0\/XLOGIC\<6\>\/MPM15_g N_VDD_XI0\/XLOGIC\<6\>\/MPM15_s \
 N_VDD_XI0\/XLOGIC\<0\>\/MPM0_b ) P_12_LLRVT l=6e-08 w=4e-07 ad=6.4e-14 \
 as=4e-14 pd=1.12e-06 ps=6e-07 nrd=0 nrs=0 sa=1.2e-06 sb=1.6e-07 sca=26.6515 \
 scb=0.0283728 scc=0.00289506
mXI0\/XLOGIC\<6\>\/MPM16 ( \
 N_XI0\/XLOGIC\<6\>\/NET011_XI0\/XLOGIC\<6\>\/MPM16_d \
 N_CTR\<0\>_XI0\/XLOGIC\<6\>\/MPM16_g N_VDD_XI0\/XLOGIC\<6\>\/MPM16_s \
 N_VDD_XI0\/XLOGIC\<0\>\/MPM0_b ) P_12_LLRVT l=6e-08 w=4e-07 ad=4e-14 as=4e-14 \
 pd=6e-07 ps=6e-07 nrd=0 nrs=0 sa=9.4e-07 sb=4.2e-07 sca=26.6484 scb=0.0283728 \
 scc=0.00289506
mXI0\/XLOGIC\<6\>\/MPM0 ( N_XI0\/XLOGIC\<6\>\/NET16_XI0\/XLOGIC\<6\>\/MPM0_d \
 N_B\<6\>_XI0\/XLOGIC\<6\>\/MPM0_g N_VDD_XI0\/XLOGIC\<6\>\/MPM0_s \
 N_VDD_XI0\/XLOGIC\<0\>\/MPM0_b ) P_12_LLRVT l=6e-08 w=4e-07 ad=4e-14 \
 as=6.4e-14 pd=6e-07 ps=1.12e-06 nrd=0 nrs=0 sa=1.6e-07 sb=1.2e-06 sca=26.6406 \
 scb=0.0283728 scc=0.00289506
mXI0\/XLOGIC\<7\>\/MPM1 ( N_X\<7\>_XI0\/XLOGIC\<7\>\/MPM1_d \
 N_CTR\<1\>_XI0\/XLOGIC\<7\>\/MPM1_g \
 N_XI0\/XLOGIC\<7\>\/NET16_XI0\/XLOGIC\<7\>\/MPM1_s \
 N_VDD_XI0\/XLOGIC\<0\>\/MPM0_b ) P_12_LLRVT l=6e-08 w=4e-07 ad=4e-14 as=4e-14 \
 pd=6e-07 ps=6e-07 nrd=0 nrs=0 sa=4.2e-07 sb=9.4e-07 sca=26.8426 scb=0.0283728 \
 scc=0.00289506
mXI0\/XLOGIC\<7\>\/MPM17 ( N_X\<7\>_XI0\/XLOGIC\<7\>\/MPM17_d \
 N_A\<7\>_XI0\/XLOGIC\<7\>\/MPM17_g \
 N_XI0\/XLOGIC\<7\>\/NET011_XI0\/XLOGIC\<7\>\/MPM17_s \
 N_VDD_XI0\/XLOGIC\<0\>\/MPM0_b ) P_12_LLRVT l=6e-08 w=4e-07 ad=4e-14 as=4e-14 \
 pd=6e-07 ps=6e-07 nrd=0 nrs=0 sa=6.8e-07 sb=6.8e-07 sca=26.8773 scb=0.0283728 \
 scc=0.00289506
mXI0\/XLOGIC\<7\>\/MPM15 ( \
 N_XI0\/XLOGIC\<7\>\/NET011_XI0\/XLOGIC\<7\>\/MPM15_d \
 N_B\<7\>_XI0\/XLOGIC\<7\>\/MPM15_g N_VDD_XI0\/XLOGIC\<7\>\/MPM15_s \
 N_VDD_XI0\/XLOGIC\<0\>\/MPM0_b ) P_12_LLRVT l=6e-08 w=4e-07 ad=6.4e-14 \
 as=4e-14 pd=1.12e-06 ps=6e-07 nrd=0 nrs=0 sa=1.2e-06 sb=1.6e-07 sca=26.9734 \
 scb=0.028373 scc=0.00289506
mXI0\/XLOGIC\<7\>\/MPM16 ( \
 N_XI0\/XLOGIC\<7\>\/NET011_XI0\/XLOGIC\<7\>\/MPM16_d \
 N_CTR\<0\>_XI0\/XLOGIC\<7\>\/MPM16_g N_VDD_XI0\/XLOGIC\<7\>\/MPM16_s \
 N_VDD_XI0\/XLOGIC\<0\>\/MPM0_b ) P_12_LLRVT l=6e-08 w=4e-07 ad=4e-14 as=4e-14 \
 pd=6e-07 ps=6e-07 nrd=0 nrs=0 sa=9.4e-07 sb=4.2e-07 sca=26.9201 scb=0.0283729 \
 scc=0.00289506
mXI0\/XLOGIC\<7\>\/MPM0 ( N_XI0\/XLOGIC\<7\>\/NET16_XI0\/XLOGIC\<7\>\/MPM0_d \
 N_B\<7\>_XI0\/XLOGIC\<7\>\/MPM0_g N_VDD_XI0\/XLOGIC\<7\>\/MPM0_s \
 N_VDD_XI0\/XLOGIC\<0\>\/MPM0_b ) P_12_LLRVT l=6e-08 w=4e-07 ad=4e-14 \
 as=6.4e-14 pd=6e-07 ps=1.12e-06 nrd=0 nrs=0 sa=1.6e-07 sb=1.2e-06 sca=26.8139 \
 scb=0.0283728 scc=0.00289506
mXI4\/XI18\/MPM16 ( N_XI4\/XI18\/NET248_XI4\/XI18\/MPM16_d \
 N_GND_XI4\/XI18\/MPM16_g N_XI4\/XI18\/NET247_XI4\/XI18\/MPM16_s \
 N_VDD_XI4\/XI18\/MPM0_b ) P_12_LLRVT l=6e-08 w=8e-07 ad=8e-14 as=8e-14 \
 pd=1e-06 ps=1e-06 nrd=0 nrs=0 sa=6.8e-07 sb=2.76e-06 sca=37.8517 \
 scb=0.0289498 scc=0.00362077
mXI4\/XI18\/MPM21 ( N_XI4\/XI18\/NET255_XI4\/XI18\/MPM21_d \
 N_XI4\/XI18\/NET248_XI4\/XI18\/MPM21_g N_XI4\/XI18\/NET253_XI4\/XI18\/MPM21_s \
 N_VDD_XI4\/XI18\/MPM0_b ) P_12_LLRVT l=6e-08 w=8e-07 ad=8e-14 as=8e-14 \
 pd=1e-06 ps=1e-06 nrd=0 nrs=0 sa=2.24e-06 sb=1.2e-06 sca=33.7574 \
 scb=0.0231451 scc=0.00354069
mXI4\/XI18\/MPM0 ( N_XI4\/NET12_XI4\/XI18\/MPM0_d \
 N_XI4\/XI18\/NET248_XI4\/XI18\/MPM0_g N_VDD_XI4\/XI18\/MPM0_s \
 N_VDD_XI4\/XI18\/MPM0_b ) P_12_LLRVT l=6e-08 w=8e-07 ad=1.28e-13 as=1.28e-13 \
 pd=1.92e-06 ps=1.92e-06 nrd=0 nrs=0 sa=1.6e-07 sb=1.6e-07 sca=67.2385 \
 scb=0.0541391 scc=0.00924912
mXI4\/XI18\/MPM28 ( N_S\<0\>_XI4\/XI18\/MPM28_d \
 N_XI4\/XI18\/NET255_XI4\/XI18\/MPM28_g N_VDD_XI4\/XI18\/MPM28_s \
 N_VDD_XI4\/XI18\/MPM0_b ) P_12_LLRVT l=6e-08 w=8e-07 ad=1.28e-13 as=8e-14 \
 pd=1.92e-06 ps=1e-06 nrd=0 nrs=0 sa=3.28e-06 sb=1.6e-07 sca=36.3137 \
 scb=0.0262201 scc=0.00355988
mXI4\/XI9\/MPM0 ( N_XI4\/NET16_XI4\/XI9\/MPM0_d \
 N_XI4\/XI9\/NET35_XI4\/XI9\/MPM0_g N_VDD_XI4\/XI9\/MPM0_s \
 N_VDD_XI4\/XI18\/MPM0_b ) P_12_LLRVT l=6e-08 w=8e-07 ad=1.28e-13 as=1.28e-13 \
 pd=1.92e-06 ps=1.92e-06 nrd=0 nrs=0 sa=1.6e-07 sb=1.6e-07 sca=67.2385 \
 scb=0.0541391 scc=0.00924912
mXI4\/XI9\/MPM28 ( N_S\<1\>_XI4\/XI9\/MPM28_d \
 N_XI4\/XI9\/NET7_XI4\/XI9\/MPM28_g N_VDD_XI4\/XI9\/MPM28_s \
 N_VDD_XI4\/XI18\/MPM0_b ) P_12_LLRVT l=6e-08 w=8e-07 ad=1.28e-13 as=8e-14 \
 pd=1.92e-06 ps=1e-06 nrd=0 nrs=0 sa=3.28e-06 sb=1.6e-07 sca=36.3137 \
 scb=0.0262201 scc=0.00355988
mXI4\/XI10\/MPM0 ( N_XI4\/NET18_XI4\/XI10\/MPM0_d \
 N_XI4\/XI10\/NET35_XI4\/XI10\/MPM0_g N_VDD_XI4\/XI10\/MPM0_s \
 N_VDD_XI4\/XI18\/MPM0_b ) P_12_LLRVT l=6e-08 w=8e-07 ad=1.28e-13 as=1.28e-13 \
 pd=1.92e-06 ps=1.92e-06 nrd=0 nrs=0 sa=1.6e-07 sb=1.6e-07 sca=67.2385 \
 scb=0.0541391 scc=0.00924912
mXI4\/XI10\/MPM28 ( N_S\<2\>_XI4\/XI10\/MPM28_d \
 N_XI4\/XI10\/NET7_XI4\/XI10\/MPM28_g N_VDD_XI4\/XI10\/MPM28_s \
 N_VDD_XI4\/XI18\/MPM0_b ) P_12_LLRVT l=6e-08 w=8e-07 ad=1.28e-13 as=8e-14 \
 pd=1.92e-06 ps=1e-06 nrd=0 nrs=0 sa=3.28e-06 sb=1.6e-07 sca=36.3137 \
 scb=0.0262201 scc=0.00355988
mXI4\/XI11\/MPM0 ( N_XI4\/NET20_XI4\/XI11\/MPM0_d \
 N_XI4\/XI11\/NET35_XI4\/XI11\/MPM0_g N_VDD_XI4\/XI11\/MPM0_s \
 N_VDD_XI4\/XI18\/MPM0_b ) P_12_LLRVT l=6e-08 w=8e-07 ad=1.28e-13 as=1.28e-13 \
 pd=1.92e-06 ps=1.92e-06 nrd=0 nrs=0 sa=1.6e-07 sb=1.6e-07 sca=67.2385 \
 scb=0.0541391 scc=0.00924912
mXI4\/XI11\/MPM28 ( N_S\<3\>_XI4\/XI11\/MPM28_d \
 N_XI4\/XI11\/NET7_XI4\/XI11\/MPM28_g N_VDD_XI4\/XI11\/MPM28_s \
 N_VDD_XI4\/XI18\/MPM0_b ) P_12_LLRVT l=6e-08 w=8e-07 ad=1.28e-13 as=8e-14 \
 pd=1.92e-06 ps=1e-06 nrd=0 nrs=0 sa=3.28e-06 sb=1.6e-07 sca=36.3137 \
 scb=0.0262201 scc=0.00355988
mXI4\/XI12\/MPM0 ( N_XI4\/NET22_XI4\/XI12\/MPM0_d \
 N_XI4\/XI12\/NET35_XI4\/XI12\/MPM0_g N_VDD_XI4\/XI12\/MPM0_s \
 N_VDD_XI4\/XI18\/MPM0_b ) P_12_LLRVT l=6e-08 w=8e-07 ad=1.28e-13 as=1.28e-13 \
 pd=1.92e-06 ps=1.92e-06 nrd=0 nrs=0 sa=1.6e-07 sb=1.6e-07 sca=67.2385 \
 scb=0.0541391 scc=0.00924912
mXI4\/XI12\/MPM28 ( N_S\<4\>_XI4\/XI12\/MPM28_d \
 N_XI4\/XI12\/NET7_XI4\/XI12\/MPM28_g N_VDD_XI4\/XI12\/MPM28_s \
 N_VDD_XI4\/XI18\/MPM0_b ) P_12_LLRVT l=6e-08 w=8e-07 ad=1.28e-13 as=8e-14 \
 pd=1.92e-06 ps=1e-06 nrd=0 nrs=0 sa=3.28e-06 sb=1.6e-07 sca=36.3137 \
 scb=0.0262201 scc=0.00355988
mXI4\/XI13\/MPM0 ( N_XI4\/NET24_XI4\/XI13\/MPM0_d \
 N_XI4\/XI13\/NET35_XI4\/XI13\/MPM0_g N_VDD_XI4\/XI13\/MPM0_s \
 N_VDD_XI4\/XI18\/MPM0_b ) P_12_LLRVT l=6e-08 w=8e-07 ad=1.28e-13 as=1.28e-13 \
 pd=1.92e-06 ps=1.92e-06 nrd=0 nrs=0 sa=1.6e-07 sb=1.6e-07 sca=67.2385 \
 scb=0.0541391 scc=0.00924912
mXI4\/XI13\/MPM28 ( N_S\<5\>_XI4\/XI13\/MPM28_d \
 N_XI4\/XI13\/NET7_XI4\/XI13\/MPM28_g N_VDD_XI4\/XI13\/MPM28_s \
 N_VDD_XI4\/XI18\/MPM0_b ) P_12_LLRVT l=6e-08 w=8e-07 ad=1.28e-13 as=8e-14 \
 pd=1.92e-06 ps=1e-06 nrd=0 nrs=0 sa=3.28e-06 sb=1.6e-07 sca=36.3137 \
 scb=0.0262201 scc=0.00355988
mXI4\/XI14\/MPM0 ( N_XI4\/NET26_XI4\/XI14\/MPM0_d \
 N_XI4\/XI14\/NET35_XI4\/XI14\/MPM0_g N_VDD_XI4\/XI14\/MPM0_s \
 N_VDD_XI4\/XI18\/MPM0_b ) P_12_LLRVT l=6e-08 w=8e-07 ad=1.28e-13 as=1.28e-13 \
 pd=1.92e-06 ps=1.92e-06 nrd=0 nrs=0 sa=1.6e-07 sb=1.6e-07 sca=67.2385 \
 scb=0.0541391 scc=0.00924912
mXI4\/XI14\/MPM28 ( N_S\<6\>_XI4\/XI14\/MPM28_d \
 N_XI4\/XI14\/NET7_XI4\/XI14\/MPM28_g N_VDD_XI4\/XI14\/MPM28_s \
 N_VDD_XI4\/XI18\/MPM0_b ) P_12_LLRVT l=6e-08 w=8e-07 ad=1.28e-13 as=8e-14 \
 pd=1.92e-06 ps=1e-06 nrd=0 nrs=0 sa=3.28e-06 sb=1.6e-07 sca=36.3137 \
 scb=0.0262201 scc=0.00355988
mXI4\/XI19\/MPM0 ( N_XI4\/XI19\/NET250_XI4\/XI19\/MPM0_d \
 N_XI4\/XI19\/NET248_XI4\/XI19\/MPM0_g N_VDD_XI4\/XI19\/MPM0_s \
 N_VDD_XI4\/XI18\/MPM0_b ) P_12_LLRVT l=6e-08 w=8e-07 ad=1.28e-13 as=1.28e-13 \
 pd=1.92e-06 ps=1.92e-06 nrd=0 nrs=0 sa=1.6e-07 sb=1.6e-07 sca=67.2385 \
 scb=0.0541391 scc=0.00924912
mXI4\/XI19\/MPM28 ( N_S\<7\>_XI4\/XI19\/MPM28_d \
 N_XI4\/XI19\/NET255_XI4\/XI19\/MPM28_g N_VDD_XI4\/XI19\/MPM28_s \
 N_VDD_XI4\/XI18\/MPM0_b ) P_12_LLRVT l=6e-08 w=8e-07 ad=1.28e-13 as=8e-14 \
 pd=1.92e-06 ps=1e-06 nrd=0 nrs=0 sa=3.28e-06 sb=1.6e-07 sca=36.3137 \
 scb=0.0262201 scc=0.00355988
mXI4\/XI18\/MNM6 ( N_XI4\/NET12_XI4\/XI18\/MNM6_d \
 N_XI4\/XI18\/NET248_XI4\/XI18\/MNM6_g N_GND_XI4\/XI18\/MNM6_s \
 N_GND_XI4\/XI18\/MNM6_b ) N_12_LLRVT l=6e-08 w=4e-07 ad=6.4e-14 as=6.4e-14 \
 pd=1.12e-06 ps=1.12e-06 nrd=0 nrs=0 sa=1.6e-07 sb=1.6e-07 sca=0.602605 \
 scb=2.67635e-06 scc=7.14388e-12
mXI4\/XI18\/MNM13 ( N_S\<0\>_XI4\/XI18\/MNM13_d \
 N_XI4\/XI18\/NET255_XI4\/XI18\/MNM13_g N_GND_XI4\/XI18\/MNM13_s \
 N_GND_XI4\/XI18\/MNM6_b ) N_12_LLRVT l=6e-08 w=4e-07 ad=6.4e-14 as=4e-14 \
 pd=1.12e-06 ps=6e-07 nrd=0 nrs=0 sa=3.28e-06 sb=1.6e-07 sca=0.602605 \
 scb=2.67635e-06 scc=7.14388e-12
mXI4\/XI9\/MNM6 ( N_XI4\/NET16_XI4\/XI9\/MNM6_d \
 N_XI4\/XI9\/NET35_XI4\/XI9\/MNM6_g N_GND_XI4\/XI9\/MNM6_s \
 N_GND_XI4\/XI18\/MNM6_b ) N_12_LLRVT l=6e-08 w=4e-07 ad=6.4e-14 as=6.4e-14 \
 pd=1.12e-06 ps=1.12e-06 nrd=0 nrs=0 sa=1.6e-07 sb=1.6e-07 sca=0.602605 \
 scb=2.67635e-06 scc=7.14388e-12
mXI4\/XI9\/MNM13 ( N_S\<1\>_XI4\/XI9\/MNM13_d \
 N_XI4\/XI9\/NET7_XI4\/XI9\/MNM13_g N_GND_XI4\/XI9\/MNM13_s \
 N_GND_XI4\/XI18\/MNM6_b ) N_12_LLRVT l=6e-08 w=4e-07 ad=6.4e-14 as=4e-14 \
 pd=1.12e-06 ps=6e-07 nrd=0 nrs=0 sa=3.28e-06 sb=1.6e-07 sca=0.602605 \
 scb=2.67635e-06 scc=7.14388e-12
mXI4\/XI10\/MNM6 ( N_XI4\/NET18_XI4\/XI10\/MNM6_d \
 N_XI4\/XI10\/NET35_XI4\/XI10\/MNM6_g N_GND_XI4\/XI10\/MNM6_s \
 N_GND_XI4\/XI18\/MNM6_b ) N_12_LLRVT l=6e-08 w=4e-07 ad=6.4e-14 as=6.4e-14 \
 pd=1.12e-06 ps=1.12e-06 nrd=0 nrs=0 sa=1.6e-07 sb=1.6e-07 sca=0.602605 \
 scb=2.67635e-06 scc=7.14388e-12
mXI4\/XI10\/MNM13 ( N_S\<2\>_XI4\/XI10\/MNM13_d \
 N_XI4\/XI10\/NET7_XI4\/XI10\/MNM13_g N_GND_XI4\/XI10\/MNM13_s \
 N_GND_XI4\/XI18\/MNM6_b ) N_12_LLRVT l=6e-08 w=4e-07 ad=6.4e-14 as=4e-14 \
 pd=1.12e-06 ps=6e-07 nrd=0 nrs=0 sa=3.28e-06 sb=1.6e-07 sca=0.602605 \
 scb=2.67635e-06 scc=7.14388e-12
mXI4\/XI11\/MNM6 ( N_XI4\/NET20_XI4\/XI11\/MNM6_d \
 N_XI4\/XI11\/NET35_XI4\/XI11\/MNM6_g N_GND_XI4\/XI11\/MNM6_s \
 N_GND_XI4\/XI18\/MNM6_b ) N_12_LLRVT l=6e-08 w=4e-07 ad=6.4e-14 as=6.4e-14 \
 pd=1.12e-06 ps=1.12e-06 nrd=0 nrs=0 sa=1.6e-07 sb=1.6e-07 sca=0.602605 \
 scb=2.67635e-06 scc=7.14388e-12
mXI4\/XI11\/MNM13 ( N_S\<3\>_XI4\/XI11\/MNM13_d \
 N_XI4\/XI11\/NET7_XI4\/XI11\/MNM13_g N_GND_XI4\/XI11\/MNM13_s \
 N_GND_XI4\/XI18\/MNM6_b ) N_12_LLRVT l=6e-08 w=4e-07 ad=6.4e-14 as=4e-14 \
 pd=1.12e-06 ps=6e-07 nrd=0 nrs=0 sa=3.28e-06 sb=1.6e-07 sca=0.602605 \
 scb=2.67635e-06 scc=7.14388e-12
mXI4\/XI12\/MNM6 ( N_XI4\/NET22_XI4\/XI12\/MNM6_d \
 N_XI4\/XI12\/NET35_XI4\/XI12\/MNM6_g N_GND_XI4\/XI12\/MNM6_s \
 N_GND_XI4\/XI18\/MNM6_b ) N_12_LLRVT l=6e-08 w=4e-07 ad=6.4e-14 as=6.4e-14 \
 pd=1.12e-06 ps=1.12e-06 nrd=0 nrs=0 sa=1.6e-07 sb=1.6e-07 sca=0.602605 \
 scb=2.67635e-06 scc=7.14388e-12
mXI4\/XI12\/MNM13 ( N_S\<4\>_XI4\/XI12\/MNM13_d \
 N_XI4\/XI12\/NET7_XI4\/XI12\/MNM13_g N_GND_XI4\/XI12\/MNM13_s \
 N_GND_XI4\/XI18\/MNM6_b ) N_12_LLRVT l=6e-08 w=4e-07 ad=6.4e-14 as=4e-14 \
 pd=1.12e-06 ps=6e-07 nrd=0 nrs=0 sa=3.28e-06 sb=1.6e-07 sca=0.602605 \
 scb=2.67635e-06 scc=7.14388e-12
mXI4\/XI13\/MNM6 ( N_XI4\/NET24_XI4\/XI13\/MNM6_d \
 N_XI4\/XI13\/NET35_XI4\/XI13\/MNM6_g N_GND_XI4\/XI13\/MNM6_s \
 N_GND_XI4\/XI18\/MNM6_b ) N_12_LLRVT l=6e-08 w=4e-07 ad=6.4e-14 as=6.4e-14 \
 pd=1.12e-06 ps=1.12e-06 nrd=0 nrs=0 sa=1.6e-07 sb=1.6e-07 sca=0.602605 \
 scb=2.67635e-06 scc=7.14388e-12
mXI4\/XI13\/MNM13 ( N_S\<5\>_XI4\/XI13\/MNM13_d \
 N_XI4\/XI13\/NET7_XI4\/XI13\/MNM13_g N_GND_XI4\/XI13\/MNM13_s \
 N_GND_XI4\/XI18\/MNM6_b ) N_12_LLRVT l=6e-08 w=4e-07 ad=6.4e-14 as=4e-14 \
 pd=1.12e-06 ps=6e-07 nrd=0 nrs=0 sa=3.28e-06 sb=1.6e-07 sca=0.602605 \
 scb=2.67635e-06 scc=7.14388e-12
mXI4\/XI14\/MNM6 ( N_XI4\/NET26_XI4\/XI14\/MNM6_d \
 N_XI4\/XI14\/NET35_XI4\/XI14\/MNM6_g N_GND_XI4\/XI14\/MNM6_s \
 N_GND_XI4\/XI18\/MNM6_b ) N_12_LLRVT l=6e-08 w=4e-07 ad=6.4e-14 as=6.4e-14 \
 pd=1.12e-06 ps=1.12e-06 nrd=0 nrs=0 sa=1.6e-07 sb=1.6e-07 sca=0.602605 \
 scb=2.67635e-06 scc=7.14388e-12
mXI4\/XI14\/MNM13 ( N_S\<6\>_XI4\/XI14\/MNM13_d \
 N_XI4\/XI14\/NET7_XI4\/XI14\/MNM13_g N_GND_XI4\/XI14\/MNM13_s \
 N_GND_XI4\/XI18\/MNM6_b ) N_12_LLRVT l=6e-08 w=4e-07 ad=6.4e-14 as=4e-14 \
 pd=1.12e-06 ps=6e-07 nrd=0 nrs=0 sa=3.28e-06 sb=1.6e-07 sca=0.602605 \
 scb=2.67635e-06 scc=7.14388e-12
mXI4\/XI19\/MNM6 ( N_XI4\/XI19\/NET250_XI4\/XI19\/MNM6_d \
 N_XI4\/XI19\/NET248_XI4\/XI19\/MNM6_g N_GND_XI4\/XI19\/MNM6_s \
 N_GND_XI4\/XI18\/MNM6_b ) N_12_LLRVT l=6e-08 w=4e-07 ad=6.4e-14 as=6.4e-14 \
 pd=1.12e-06 ps=1.12e-06 nrd=0 nrs=0 sa=1.6e-07 sb=1.6e-07 sca=0.602605 \
 scb=2.67635e-06 scc=7.14388e-12
mXI4\/XI19\/MNM13 ( N_S\<7\>_XI4\/XI19\/MNM13_d \
 N_XI4\/XI19\/NET255_XI4\/XI19\/MNM13_g N_GND_XI4\/XI19\/MNM13_s \
 N_GND_XI4\/XI18\/MNM6_b ) N_12_LLRVT l=6e-08 w=4e-07 ad=6.4e-14 as=4e-14 \
 pd=1.12e-06 ps=6e-07 nrd=0 nrs=0 sa=3.28e-06 sb=1.6e-07 sca=0.602605 \
 scb=2.67635e-06 scc=7.14388e-12
mXI3\/XMUX\<0\>\/MNM3 ( N_O\<0\>_XI3\/XMUX\<0\>\/MNM3_d \
 N_XI3\/XMUX\<0\>\/NET17_XI3\/XMUX\<0\>\/MNM3_g N_GND_XI3\/XMUX\<0\>\/MNM3_s \
 N_GND_XI4\/XI18\/MNM6_b ) N_12_LLRVT l=6e-08 w=2e-07 ad=3.2e-14 as=2e-14 \
 pd=7.2e-07 ps=4e-07 nrd=0 nrs=0 sa=1.46e-06 sb=1.6e-07 sca=8.65274 \
 scb=0.00797851 scc=9.45389e-05
mXI3\/XMUX\<0\>\/MNM0 ( N_XI3\/XMUX\<0\>\/S_INV_XI3\/XMUX\<0\>\/MNM0_d \
 N_SEL_XI3\/XMUX\<0\>\/MNM0_g N_GND_XI3\/XMUX\<0\>\/MNM0_s \
 N_GND_XI4\/XI18\/MNM6_b ) N_12_LLRVT l=6e-08 w=2e-07 ad=3.2e-14 as=2e-14 \
 pd=7.2e-07 ps=4e-07 nrd=0 nrs=0 sa=1.6e-07 sb=1.46e-06 sca=8.65274 \
 scb=0.00797851 scc=9.45389e-05
mXI3\/XMUX\<0\>\/MNM16 ( N_XI3\/XMUX\<0\>\/NET020_XI3\/XMUX\<0\>\/MNM16_d \
 N_S\<0\>_XI3\/XMUX\<0\>\/MNM16_g N_GND_XI3\/XMUX\<0\>\/MNM16_s \
 N_GND_XI4\/XI18\/MNM6_b ) N_12_LLRVT l=6e-08 w=2e-07 ad=2e-14 as=2e-14 \
 pd=4e-07 ps=4e-07 nrd=0 nrs=0 sa=1.2e-06 sb=4.2e-07 sca=8.65274 \
 scb=0.00797851 scc=9.45389e-05
mXI3\/XMUX\<0\>\/MNM15 ( N_XI3\/XMUX\<0\>\/NET17_XI3\/XMUX\<0\>\/MNM15_d \
 N_SEL_XI3\/XMUX\<0\>\/MNM15_g \
 N_XI3\/XMUX\<0\>\/NET020_XI3\/XMUX\<0\>\/MNM15_s N_GND_XI4\/XI18\/MNM6_b ) \
 N_12_LLRVT l=6e-08 w=2e-07 ad=2e-14 as=2e-14 pd=4e-07 ps=4e-07 nrd=0 nrs=0 \
 sa=9.4e-07 sb=6.8e-07 sca=8.65274 scb=0.00797851 scc=9.45389e-05
mXI3\/XMUX\<0\>\/MNM4 ( N_XI3\/XMUX\<0\>\/NET20_XI3\/XMUX\<0\>\/MNM4_d \
 N_X\<0\>_XI3\/XMUX\<0\>\/MNM4_g N_GND_XI3\/XMUX\<0\>\/MNM4_s \
 N_GND_XI4\/XI18\/MNM6_b ) N_12_LLRVT l=6e-08 w=2e-07 ad=2e-14 as=2e-14 \
 pd=4e-07 ps=4e-07 nrd=0 nrs=0 sa=4.2e-07 sb=1.2e-06 sca=8.65274 \
 scb=0.00797851 scc=9.45389e-05
mXI3\/XMUX\<0\>\/MNM1 ( N_XI3\/XMUX\<0\>\/NET17_XI3\/XMUX\<0\>\/MNM1_d \
 N_XI3\/XMUX\<0\>\/S_INV_XI3\/XMUX\<0\>\/MNM1_g \
 N_XI3\/XMUX\<0\>\/NET20_XI3\/XMUX\<0\>\/MNM1_s N_GND_XI4\/XI18\/MNM6_b ) \
 N_12_LLRVT l=6e-08 w=2e-07 ad=2e-14 as=2e-14 pd=4e-07 ps=4e-07 nrd=0 nrs=0 \
 sa=6.8e-07 sb=9.4e-07 sca=8.65274 scb=0.00797851 scc=9.45389e-05
mXI3\/XMUX\<1\>\/MNM3 ( N_O\<1\>_XI3\/XMUX\<1\>\/MNM3_d \
 N_XI3\/XMUX\<1\>\/NET17_XI3\/XMUX\<1\>\/MNM3_g N_GND_XI3\/XMUX\<1\>\/MNM3_s \
 N_GND_XI4\/XI18\/MNM6_b ) N_12_LLRVT l=6e-08 w=2e-07 ad=3.2e-14 as=2e-14 \
 pd=7.2e-07 ps=4e-07 nrd=0 nrs=0 sa=1.46e-06 sb=1.6e-07 sca=8.65274 \
 scb=0.00797851 scc=9.45389e-05
mXI3\/XMUX\<1\>\/MNM0 ( N_XI3\/XMUX\<1\>\/S_INV_XI3\/XMUX\<1\>\/MNM0_d \
 N_SEL_XI3\/XMUX\<1\>\/MNM0_g N_GND_XI3\/XMUX\<1\>\/MNM0_s \
 N_GND_XI4\/XI18\/MNM6_b ) N_12_LLRVT l=6e-08 w=2e-07 ad=3.2e-14 as=2e-14 \
 pd=7.2e-07 ps=4e-07 nrd=0 nrs=0 sa=1.6e-07 sb=1.46e-06 sca=8.65274 \
 scb=0.00797851 scc=9.45389e-05
mXI3\/XMUX\<1\>\/MNM16 ( N_XI3\/XMUX\<1\>\/NET020_XI3\/XMUX\<1\>\/MNM16_d \
 N_S\<1\>_XI3\/XMUX\<1\>\/MNM16_g N_GND_XI3\/XMUX\<1\>\/MNM16_s \
 N_GND_XI4\/XI18\/MNM6_b ) N_12_LLRVT l=6e-08 w=2e-07 ad=2e-14 as=2e-14 \
 pd=4e-07 ps=4e-07 nrd=0 nrs=0 sa=1.2e-06 sb=4.2e-07 sca=8.65274 \
 scb=0.00797851 scc=9.45389e-05
mXI3\/XMUX\<1\>\/MNM15 ( N_XI3\/XMUX\<1\>\/NET17_XI3\/XMUX\<1\>\/MNM15_d \
 N_SEL_XI3\/XMUX\<1\>\/MNM15_g \
 N_XI3\/XMUX\<1\>\/NET020_XI3\/XMUX\<1\>\/MNM15_s N_GND_XI4\/XI18\/MNM6_b ) \
 N_12_LLRVT l=6e-08 w=2e-07 ad=2e-14 as=2e-14 pd=4e-07 ps=4e-07 nrd=0 nrs=0 \
 sa=9.4e-07 sb=6.8e-07 sca=8.65274 scb=0.00797851 scc=9.45389e-05
mXI3\/XMUX\<1\>\/MNM4 ( N_XI3\/XMUX\<1\>\/NET20_XI3\/XMUX\<1\>\/MNM4_d \
 N_X\<1\>_XI3\/XMUX\<1\>\/MNM4_g N_GND_XI3\/XMUX\<1\>\/MNM4_s \
 N_GND_XI4\/XI18\/MNM6_b ) N_12_LLRVT l=6e-08 w=2e-07 ad=2e-14 as=2e-14 \
 pd=4e-07 ps=4e-07 nrd=0 nrs=0 sa=4.2e-07 sb=1.2e-06 sca=8.65274 \
 scb=0.00797851 scc=9.45389e-05
mXI3\/XMUX\<1\>\/MNM1 ( N_XI3\/XMUX\<1\>\/NET17_XI3\/XMUX\<1\>\/MNM1_d \
 N_XI3\/XMUX\<1\>\/S_INV_XI3\/XMUX\<1\>\/MNM1_g \
 N_XI3\/XMUX\<1\>\/NET20_XI3\/XMUX\<1\>\/MNM1_s N_GND_XI4\/XI18\/MNM6_b ) \
 N_12_LLRVT l=6e-08 w=2e-07 ad=2e-14 as=2e-14 pd=4e-07 ps=4e-07 nrd=0 nrs=0 \
 sa=6.8e-07 sb=9.4e-07 sca=8.65274 scb=0.00797851 scc=9.45389e-05
mXI3\/XMUX\<2\>\/MNM3 ( N_O\<2\>_XI3\/XMUX\<2\>\/MNM3_d \
 N_XI3\/XMUX\<2\>\/NET17_XI3\/XMUX\<2\>\/MNM3_g N_GND_XI3\/XMUX\<2\>\/MNM3_s \
 N_GND_XI4\/XI18\/MNM6_b ) N_12_LLRVT l=6e-08 w=2e-07 ad=3.2e-14 as=2e-14 \
 pd=7.2e-07 ps=4e-07 nrd=0 nrs=0 sa=1.46e-06 sb=1.6e-07 sca=8.65274 \
 scb=0.00797851 scc=9.45389e-05
mXI3\/XMUX\<2\>\/MNM0 ( N_XI3\/XMUX\<2\>\/S_INV_XI3\/XMUX\<2\>\/MNM0_d \
 N_SEL_XI3\/XMUX\<2\>\/MNM0_g N_GND_XI3\/XMUX\<2\>\/MNM0_s \
 N_GND_XI4\/XI18\/MNM6_b ) N_12_LLRVT l=6e-08 w=2e-07 ad=3.2e-14 as=2e-14 \
 pd=7.2e-07 ps=4e-07 nrd=0 nrs=0 sa=1.6e-07 sb=1.46e-06 sca=8.65274 \
 scb=0.00797851 scc=9.45389e-05
mXI3\/XMUX\<2\>\/MNM16 ( N_XI3\/XMUX\<2\>\/NET020_XI3\/XMUX\<2\>\/MNM16_d \
 N_S\<2\>_XI3\/XMUX\<2\>\/MNM16_g N_GND_XI3\/XMUX\<2\>\/MNM16_s \
 N_GND_XI4\/XI18\/MNM6_b ) N_12_LLRVT l=6e-08 w=2e-07 ad=2e-14 as=2e-14 \
 pd=4e-07 ps=4e-07 nrd=0 nrs=0 sa=1.2e-06 sb=4.2e-07 sca=8.65274 \
 scb=0.00797851 scc=9.45389e-05
mXI3\/XMUX\<2\>\/MNM15 ( N_XI3\/XMUX\<2\>\/NET17_XI3\/XMUX\<2\>\/MNM15_d \
 N_SEL_XI3\/XMUX\<2\>\/MNM15_g \
 N_XI3\/XMUX\<2\>\/NET020_XI3\/XMUX\<2\>\/MNM15_s N_GND_XI4\/XI18\/MNM6_b ) \
 N_12_LLRVT l=6e-08 w=2e-07 ad=2e-14 as=2e-14 pd=4e-07 ps=4e-07 nrd=0 nrs=0 \
 sa=9.4e-07 sb=6.8e-07 sca=8.65274 scb=0.00797851 scc=9.45389e-05
mXI3\/XMUX\<2\>\/MNM4 ( N_XI3\/XMUX\<2\>\/NET20_XI3\/XMUX\<2\>\/MNM4_d \
 N_X\<2\>_XI3\/XMUX\<2\>\/MNM4_g N_GND_XI3\/XMUX\<2\>\/MNM4_s \
 N_GND_XI4\/XI18\/MNM6_b ) N_12_LLRVT l=6e-08 w=2e-07 ad=2e-14 as=2e-14 \
 pd=4e-07 ps=4e-07 nrd=0 nrs=0 sa=4.2e-07 sb=1.2e-06 sca=8.65274 \
 scb=0.00797851 scc=9.45389e-05
mXI3\/XMUX\<2\>\/MNM1 ( N_XI3\/XMUX\<2\>\/NET17_XI3\/XMUX\<2\>\/MNM1_d \
 N_XI3\/XMUX\<2\>\/S_INV_XI3\/XMUX\<2\>\/MNM1_g \
 N_XI3\/XMUX\<2\>\/NET20_XI3\/XMUX\<2\>\/MNM1_s N_GND_XI4\/XI18\/MNM6_b ) \
 N_12_LLRVT l=6e-08 w=2e-07 ad=2e-14 as=2e-14 pd=4e-07 ps=4e-07 nrd=0 nrs=0 \
 sa=6.8e-07 sb=9.4e-07 sca=8.65274 scb=0.00797851 scc=9.45389e-05
mXI3\/XMUX\<3\>\/MNM3 ( N_O\<3\>_XI3\/XMUX\<3\>\/MNM3_d \
 N_XI3\/XMUX\<3\>\/NET17_XI3\/XMUX\<3\>\/MNM3_g N_GND_XI3\/XMUX\<3\>\/MNM3_s \
 N_GND_XI4\/XI18\/MNM6_b ) N_12_LLRVT l=6e-08 w=2e-07 ad=3.2e-14 as=2e-14 \
 pd=7.2e-07 ps=4e-07 nrd=0 nrs=0 sa=1.46e-06 sb=1.6e-07 sca=8.65274 \
 scb=0.00797851 scc=9.45389e-05
mXI3\/XMUX\<3\>\/MNM0 ( N_XI3\/XMUX\<3\>\/S_INV_XI3\/XMUX\<3\>\/MNM0_d \
 N_SEL_XI3\/XMUX\<3\>\/MNM0_g N_GND_XI3\/XMUX\<3\>\/MNM0_s \
 N_GND_XI4\/XI18\/MNM6_b ) N_12_LLRVT l=6e-08 w=2e-07 ad=3.2e-14 as=2e-14 \
 pd=7.2e-07 ps=4e-07 nrd=0 nrs=0 sa=1.6e-07 sb=1.46e-06 sca=8.65274 \
 scb=0.00797851 scc=9.45389e-05
mXI3\/XMUX\<3\>\/MNM16 ( N_XI3\/XMUX\<3\>\/NET020_XI3\/XMUX\<3\>\/MNM16_d \
 N_S\<3\>_XI3\/XMUX\<3\>\/MNM16_g N_GND_XI3\/XMUX\<3\>\/MNM16_s \
 N_GND_XI4\/XI18\/MNM6_b ) N_12_LLRVT l=6e-08 w=2e-07 ad=2e-14 as=2e-14 \
 pd=4e-07 ps=4e-07 nrd=0 nrs=0 sa=1.2e-06 sb=4.2e-07 sca=8.65274 \
 scb=0.00797851 scc=9.45389e-05
mXI3\/XMUX\<3\>\/MNM15 ( N_XI3\/XMUX\<3\>\/NET17_XI3\/XMUX\<3\>\/MNM15_d \
 N_SEL_XI3\/XMUX\<3\>\/MNM15_g \
 N_XI3\/XMUX\<3\>\/NET020_XI3\/XMUX\<3\>\/MNM15_s N_GND_XI4\/XI18\/MNM6_b ) \
 N_12_LLRVT l=6e-08 w=2e-07 ad=2e-14 as=2e-14 pd=4e-07 ps=4e-07 nrd=0 nrs=0 \
 sa=9.4e-07 sb=6.8e-07 sca=8.65274 scb=0.00797851 scc=9.45389e-05
mXI3\/XMUX\<3\>\/MNM4 ( N_XI3\/XMUX\<3\>\/NET20_XI3\/XMUX\<3\>\/MNM4_d \
 N_X\<3\>_XI3\/XMUX\<3\>\/MNM4_g N_GND_XI3\/XMUX\<3\>\/MNM4_s \
 N_GND_XI4\/XI18\/MNM6_b ) N_12_LLRVT l=6e-08 w=2e-07 ad=2e-14 as=2e-14 \
 pd=4e-07 ps=4e-07 nrd=0 nrs=0 sa=4.2e-07 sb=1.2e-06 sca=8.65274 \
 scb=0.00797851 scc=9.45389e-05
mXI3\/XMUX\<3\>\/MNM1 ( N_XI3\/XMUX\<3\>\/NET17_XI3\/XMUX\<3\>\/MNM1_d \
 N_XI3\/XMUX\<3\>\/S_INV_XI3\/XMUX\<3\>\/MNM1_g \
 N_XI3\/XMUX\<3\>\/NET20_XI3\/XMUX\<3\>\/MNM1_s N_GND_XI4\/XI18\/MNM6_b ) \
 N_12_LLRVT l=6e-08 w=2e-07 ad=2e-14 as=2e-14 pd=4e-07 ps=4e-07 nrd=0 nrs=0 \
 sa=6.8e-07 sb=9.4e-07 sca=8.65274 scb=0.00797851 scc=9.45389e-05
mXI3\/XMUX\<4\>\/MNM3 ( N_O\<4\>_XI3\/XMUX\<4\>\/MNM3_d \
 N_XI3\/XMUX\<4\>\/NET17_XI3\/XMUX\<4\>\/MNM3_g N_GND_XI3\/XMUX\<4\>\/MNM3_s \
 N_GND_XI4\/XI18\/MNM6_b ) N_12_LLRVT l=6e-08 w=2e-07 ad=3.2e-14 as=2e-14 \
 pd=7.2e-07 ps=4e-07 nrd=0 nrs=0 sa=1.46e-06 sb=1.6e-07 sca=8.65274 \
 scb=0.00797851 scc=9.45389e-05
mXI3\/XMUX\<4\>\/MNM0 ( N_XI3\/XMUX\<4\>\/S_INV_XI3\/XMUX\<4\>\/MNM0_d \
 N_SEL_XI3\/XMUX\<4\>\/MNM0_g N_GND_XI3\/XMUX\<4\>\/MNM0_s \
 N_GND_XI4\/XI18\/MNM6_b ) N_12_LLRVT l=6e-08 w=2e-07 ad=3.2e-14 as=2e-14 \
 pd=7.2e-07 ps=4e-07 nrd=0 nrs=0 sa=1.6e-07 sb=1.46e-06 sca=8.65274 \
 scb=0.00797851 scc=9.45389e-05
mXI3\/XMUX\<4\>\/MNM16 ( N_XI3\/XMUX\<4\>\/NET020_XI3\/XMUX\<4\>\/MNM16_d \
 N_S\<4\>_XI3\/XMUX\<4\>\/MNM16_g N_GND_XI3\/XMUX\<4\>\/MNM16_s \
 N_GND_XI4\/XI18\/MNM6_b ) N_12_LLRVT l=6e-08 w=2e-07 ad=2e-14 as=2e-14 \
 pd=4e-07 ps=4e-07 nrd=0 nrs=0 sa=1.2e-06 sb=4.2e-07 sca=8.65274 \
 scb=0.00797851 scc=9.45389e-05
mXI3\/XMUX\<4\>\/MNM15 ( N_XI3\/XMUX\<4\>\/NET17_XI3\/XMUX\<4\>\/MNM15_d \
 N_SEL_XI3\/XMUX\<4\>\/MNM15_g \
 N_XI3\/XMUX\<4\>\/NET020_XI3\/XMUX\<4\>\/MNM15_s N_GND_XI4\/XI18\/MNM6_b ) \
 N_12_LLRVT l=6e-08 w=2e-07 ad=2e-14 as=2e-14 pd=4e-07 ps=4e-07 nrd=0 nrs=0 \
 sa=9.4e-07 sb=6.8e-07 sca=8.65274 scb=0.00797851 scc=9.45389e-05
mXI3\/XMUX\<4\>\/MNM4 ( N_XI3\/XMUX\<4\>\/NET20_XI3\/XMUX\<4\>\/MNM4_d \
 N_X\<4\>_XI3\/XMUX\<4\>\/MNM4_g N_GND_XI3\/XMUX\<4\>\/MNM4_s \
 N_GND_XI4\/XI18\/MNM6_b ) N_12_LLRVT l=6e-08 w=2e-07 ad=2e-14 as=2e-14 \
 pd=4e-07 ps=4e-07 nrd=0 nrs=0 sa=4.2e-07 sb=1.2e-06 sca=8.65274 \
 scb=0.00797851 scc=9.45389e-05
mXI3\/XMUX\<4\>\/MNM1 ( N_XI3\/XMUX\<4\>\/NET17_XI3\/XMUX\<4\>\/MNM1_d \
 N_XI3\/XMUX\<4\>\/S_INV_XI3\/XMUX\<4\>\/MNM1_g \
 N_XI3\/XMUX\<4\>\/NET20_XI3\/XMUX\<4\>\/MNM1_s N_GND_XI4\/XI18\/MNM6_b ) \
 N_12_LLRVT l=6e-08 w=2e-07 ad=2e-14 as=2e-14 pd=4e-07 ps=4e-07 nrd=0 nrs=0 \
 sa=6.8e-07 sb=9.4e-07 sca=8.65274 scb=0.00797851 scc=9.45389e-05
mXI3\/XMUX\<5\>\/MNM3 ( N_O\<5\>_XI3\/XMUX\<5\>\/MNM3_d \
 N_XI3\/XMUX\<5\>\/NET17_XI3\/XMUX\<5\>\/MNM3_g N_GND_XI3\/XMUX\<5\>\/MNM3_s \
 N_GND_XI4\/XI18\/MNM6_b ) N_12_LLRVT l=6e-08 w=2e-07 ad=3.2e-14 as=2e-14 \
 pd=7.2e-07 ps=4e-07 nrd=0 nrs=0 sa=1.46e-06 sb=1.6e-07 sca=8.65274 \
 scb=0.00797851 scc=9.45389e-05
mXI3\/XMUX\<5\>\/MNM0 ( N_XI3\/XMUX\<5\>\/S_INV_XI3\/XMUX\<5\>\/MNM0_d \
 N_SEL_XI3\/XMUX\<5\>\/MNM0_g N_GND_XI3\/XMUX\<5\>\/MNM0_s \
 N_GND_XI4\/XI18\/MNM6_b ) N_12_LLRVT l=6e-08 w=2e-07 ad=3.2e-14 as=2e-14 \
 pd=7.2e-07 ps=4e-07 nrd=0 nrs=0 sa=1.6e-07 sb=1.46e-06 sca=8.65274 \
 scb=0.00797851 scc=9.45389e-05
mXI3\/XMUX\<5\>\/MNM16 ( N_XI3\/XMUX\<5\>\/NET020_XI3\/XMUX\<5\>\/MNM16_d \
 N_S\<5\>_XI3\/XMUX\<5\>\/MNM16_g N_GND_XI3\/XMUX\<5\>\/MNM16_s \
 N_GND_XI4\/XI18\/MNM6_b ) N_12_LLRVT l=6e-08 w=2e-07 ad=2e-14 as=2e-14 \
 pd=4e-07 ps=4e-07 nrd=0 nrs=0 sa=1.2e-06 sb=4.2e-07 sca=8.65274 \
 scb=0.00797851 scc=9.45389e-05
mXI3\/XMUX\<5\>\/MNM15 ( N_XI3\/XMUX\<5\>\/NET17_XI3\/XMUX\<5\>\/MNM15_d \
 N_SEL_XI3\/XMUX\<5\>\/MNM15_g \
 N_XI3\/XMUX\<5\>\/NET020_XI3\/XMUX\<5\>\/MNM15_s N_GND_XI4\/XI18\/MNM6_b ) \
 N_12_LLRVT l=6e-08 w=2e-07 ad=2e-14 as=2e-14 pd=4e-07 ps=4e-07 nrd=0 nrs=0 \
 sa=9.4e-07 sb=6.8e-07 sca=8.65274 scb=0.00797851 scc=9.45389e-05
mXI3\/XMUX\<5\>\/MNM4 ( N_XI3\/XMUX\<5\>\/NET20_XI3\/XMUX\<5\>\/MNM4_d \
 N_X\<5\>_XI3\/XMUX\<5\>\/MNM4_g N_GND_XI3\/XMUX\<5\>\/MNM4_s \
 N_GND_XI4\/XI18\/MNM6_b ) N_12_LLRVT l=6e-08 w=2e-07 ad=2e-14 as=2e-14 \
 pd=4e-07 ps=4e-07 nrd=0 nrs=0 sa=4.2e-07 sb=1.2e-06 sca=8.65274 \
 scb=0.00797851 scc=9.45389e-05
mXI3\/XMUX\<5\>\/MNM1 ( N_XI3\/XMUX\<5\>\/NET17_XI3\/XMUX\<5\>\/MNM1_d \
 N_XI3\/XMUX\<5\>\/S_INV_XI3\/XMUX\<5\>\/MNM1_g \
 N_XI3\/XMUX\<5\>\/NET20_XI3\/XMUX\<5\>\/MNM1_s N_GND_XI4\/XI18\/MNM6_b ) \
 N_12_LLRVT l=6e-08 w=2e-07 ad=2e-14 as=2e-14 pd=4e-07 ps=4e-07 nrd=0 nrs=0 \
 sa=6.8e-07 sb=9.4e-07 sca=8.65274 scb=0.00797851 scc=9.45389e-05
mXI3\/XMUX\<6\>\/MNM3 ( N_O\<6\>_XI3\/XMUX\<6\>\/MNM3_d \
 N_XI3\/XMUX\<6\>\/NET17_XI3\/XMUX\<6\>\/MNM3_g N_GND_XI3\/XMUX\<6\>\/MNM3_s \
 N_GND_XI4\/XI18\/MNM6_b ) N_12_LLRVT l=6e-08 w=2e-07 ad=3.2e-14 as=2e-14 \
 pd=7.2e-07 ps=4e-07 nrd=0 nrs=0 sa=1.46e-06 sb=1.6e-07 sca=8.65274 \
 scb=0.00797851 scc=9.45389e-05
mXI3\/XMUX\<6\>\/MNM0 ( N_XI3\/XMUX\<6\>\/S_INV_XI3\/XMUX\<6\>\/MNM0_d \
 N_SEL_XI3\/XMUX\<6\>\/MNM0_g N_GND_XI3\/XMUX\<6\>\/MNM0_s \
 N_GND_XI4\/XI18\/MNM6_b ) N_12_LLRVT l=6e-08 w=2e-07 ad=3.2e-14 as=2e-14 \
 pd=7.2e-07 ps=4e-07 nrd=0 nrs=0 sa=1.6e-07 sb=1.46e-06 sca=8.65274 \
 scb=0.00797851 scc=9.45389e-05
mXI3\/XMUX\<6\>\/MNM16 ( N_XI3\/XMUX\<6\>\/NET020_XI3\/XMUX\<6\>\/MNM16_d \
 N_S\<6\>_XI3\/XMUX\<6\>\/MNM16_g N_GND_XI3\/XMUX\<6\>\/MNM16_s \
 N_GND_XI4\/XI18\/MNM6_b ) N_12_LLRVT l=6e-08 w=2e-07 ad=2e-14 as=2e-14 \
 pd=4e-07 ps=4e-07 nrd=0 nrs=0 sa=1.2e-06 sb=4.2e-07 sca=8.65274 \
 scb=0.00797851 scc=9.45389e-05
mXI3\/XMUX\<6\>\/MNM15 ( N_XI3\/XMUX\<6\>\/NET17_XI3\/XMUX\<6\>\/MNM15_d \
 N_SEL_XI3\/XMUX\<6\>\/MNM15_g \
 N_XI3\/XMUX\<6\>\/NET020_XI3\/XMUX\<6\>\/MNM15_s N_GND_XI4\/XI18\/MNM6_b ) \
 N_12_LLRVT l=6e-08 w=2e-07 ad=2e-14 as=2e-14 pd=4e-07 ps=4e-07 nrd=0 nrs=0 \
 sa=9.4e-07 sb=6.8e-07 sca=8.65274 scb=0.00797851 scc=9.45389e-05
mXI3\/XMUX\<6\>\/MNM4 ( N_XI3\/XMUX\<6\>\/NET20_XI3\/XMUX\<6\>\/MNM4_d \
 N_X\<6\>_XI3\/XMUX\<6\>\/MNM4_g N_GND_XI3\/XMUX\<6\>\/MNM4_s \
 N_GND_XI4\/XI18\/MNM6_b ) N_12_LLRVT l=6e-08 w=2e-07 ad=2e-14 as=2e-14 \
 pd=4e-07 ps=4e-07 nrd=0 nrs=0 sa=4.2e-07 sb=1.2e-06 sca=8.65274 \
 scb=0.00797851 scc=9.45389e-05
mXI3\/XMUX\<6\>\/MNM1 ( N_XI3\/XMUX\<6\>\/NET17_XI3\/XMUX\<6\>\/MNM1_d \
 N_XI3\/XMUX\<6\>\/S_INV_XI3\/XMUX\<6\>\/MNM1_g \
 N_XI3\/XMUX\<6\>\/NET20_XI3\/XMUX\<6\>\/MNM1_s N_GND_XI4\/XI18\/MNM6_b ) \
 N_12_LLRVT l=6e-08 w=2e-07 ad=2e-14 as=2e-14 pd=4e-07 ps=4e-07 nrd=0 nrs=0 \
 sa=6.8e-07 sb=9.4e-07 sca=8.65274 scb=0.00797851 scc=9.45389e-05
mXI3\/XMUX\<7\>\/MNM3 ( N_O\<7\>_XI3\/XMUX\<7\>\/MNM3_d \
 N_XI3\/XMUX\<7\>\/NET17_XI3\/XMUX\<7\>\/MNM3_g N_GND_XI3\/XMUX\<7\>\/MNM3_s \
 N_GND_XI4\/XI18\/MNM6_b ) N_12_LLRVT l=6e-08 w=2e-07 ad=3.2e-14 as=2e-14 \
 pd=7.2e-07 ps=4e-07 nrd=0 nrs=0 sa=1.46e-06 sb=1.6e-07 sca=8.65274 \
 scb=0.00797851 scc=9.45389e-05
mXI3\/XMUX\<7\>\/MNM0 ( N_XI3\/XMUX\<7\>\/S_INV_XI3\/XMUX\<7\>\/MNM0_d \
 N_SEL_XI3\/XMUX\<7\>\/MNM0_g N_GND_XI3\/XMUX\<7\>\/MNM0_s \
 N_GND_XI4\/XI18\/MNM6_b ) N_12_LLRVT l=6e-08 w=2e-07 ad=3.2e-14 as=2e-14 \
 pd=7.2e-07 ps=4e-07 nrd=0 nrs=0 sa=1.6e-07 sb=1.46e-06 sca=8.65274 \
 scb=0.00797851 scc=9.45389e-05
mXI3\/XMUX\<7\>\/MNM16 ( N_XI3\/XMUX\<7\>\/NET020_XI3\/XMUX\<7\>\/MNM16_d \
 N_S\<7\>_XI3\/XMUX\<7\>\/MNM16_g N_GND_XI3\/XMUX\<7\>\/MNM16_s \
 N_GND_XI4\/XI18\/MNM6_b ) N_12_LLRVT l=6e-08 w=2e-07 ad=2e-14 as=2e-14 \
 pd=4e-07 ps=4e-07 nrd=0 nrs=0 sa=1.2e-06 sb=4.2e-07 sca=8.65274 \
 scb=0.00797851 scc=9.45389e-05
mXI3\/XMUX\<7\>\/MNM15 ( N_XI3\/XMUX\<7\>\/NET17_XI3\/XMUX\<7\>\/MNM15_d \
 N_SEL_XI3\/XMUX\<7\>\/MNM15_g \
 N_XI3\/XMUX\<7\>\/NET020_XI3\/XMUX\<7\>\/MNM15_s N_GND_XI4\/XI18\/MNM6_b ) \
 N_12_LLRVT l=6e-08 w=2e-07 ad=2e-14 as=2e-14 pd=4e-07 ps=4e-07 nrd=0 nrs=0 \
 sa=9.4e-07 sb=6.8e-07 sca=8.65274 scb=0.00797851 scc=9.45389e-05
mXI3\/XMUX\<7\>\/MNM4 ( N_XI3\/XMUX\<7\>\/NET20_XI3\/XMUX\<7\>\/MNM4_d \
 N_X\<7\>_XI3\/XMUX\<7\>\/MNM4_g N_GND_XI3\/XMUX\<7\>\/MNM4_s \
 N_GND_XI4\/XI18\/MNM6_b ) N_12_LLRVT l=6e-08 w=2e-07 ad=2e-14 as=2e-14 \
 pd=4e-07 ps=4e-07 nrd=0 nrs=0 sa=4.2e-07 sb=1.2e-06 sca=8.65274 \
 scb=0.00797851 scc=9.45389e-05
mXI3\/XMUX\<7\>\/MNM1 ( N_XI3\/XMUX\<7\>\/NET17_XI3\/XMUX\<7\>\/MNM1_d \
 N_XI3\/XMUX\<7\>\/S_INV_XI3\/XMUX\<7\>\/MNM1_g \
 N_XI3\/XMUX\<7\>\/NET20_XI3\/XMUX\<7\>\/MNM1_s N_GND_XI4\/XI18\/MNM6_b ) \
 N_12_LLRVT l=6e-08 w=2e-07 ad=2e-14 as=2e-14 pd=4e-07 ps=4e-07 nrd=0 nrs=0 \
 sa=6.8e-07 sb=9.4e-07 sca=8.65274 scb=0.00797851 scc=9.45389e-05
mXI4\/XI18\/MNM9 ( N_XI4\/XI18\/NET252_XI4\/XI18\/MNM9_d \
 N_GND_XI4\/XI18\/MNM9_g N_GND_XI4\/XI18\/MNM9_s N_GND_XI4\/XI18\/MNM6_b ) \
 N_12_LLRVT l=6e-08 w=4e-07 ad=4e-14 as=4e-14 pd=6e-07 ps=6e-07 nrd=0 nrs=0 \
 sa=1.98e-06 sb=1.46e-06 sca=0.602605 scb=2.67635e-06 scc=7.14388e-12
mXI4\/XI9\/MNM9 ( N_XI4\/XI9\/NET21_XI4\/XI9\/MNM9_d \
 N_XI4\/NET12_XI4\/XI9\/MNM9_g N_GND_XI4\/XI9\/MNM9_s N_GND_XI4\/XI18\/MNM6_b \
 ) N_12_LLRVT l=6e-08 w=4e-07 ad=4e-14 as=4e-14 pd=6e-07 ps=6e-07 nrd=0 nrs=0 \
 sa=1.98e-06 sb=1.46e-06 sca=0.602605 scb=2.67635e-06 scc=7.14388e-12
mXI4\/XI10\/MNM9 ( N_XI4\/XI10\/NET21_XI4\/XI10\/MNM9_d \
 N_XI4\/NET16_XI4\/XI10\/MNM9_g N_GND_XI4\/XI10\/MNM9_s \
 N_GND_XI4\/XI18\/MNM6_b ) N_12_LLRVT l=6e-08 w=4e-07 ad=4e-14 as=4e-14 \
 pd=6e-07 ps=6e-07 nrd=0 nrs=0 sa=1.98e-06 sb=1.46e-06 sca=0.602605 \
 scb=2.67635e-06 scc=7.14388e-12
mXI4\/XI11\/MNM9 ( N_XI4\/XI11\/NET21_XI4\/XI11\/MNM9_d \
 N_XI4\/NET18_XI4\/XI11\/MNM9_g N_GND_XI4\/XI11\/MNM9_s \
 N_GND_XI4\/XI18\/MNM6_b ) N_12_LLRVT l=6e-08 w=4e-07 ad=4e-14 as=4e-14 \
 pd=6e-07 ps=6e-07 nrd=0 nrs=0 sa=1.98e-06 sb=1.46e-06 sca=0.602605 \
 scb=2.67635e-06 scc=7.14388e-12
mXI4\/XI12\/MNM9 ( N_XI4\/XI12\/NET21_XI4\/XI12\/MNM9_d \
 N_XI4\/NET20_XI4\/XI12\/MNM9_g N_GND_XI4\/XI12\/MNM9_s \
 N_GND_XI4\/XI18\/MNM6_b ) N_12_LLRVT l=6e-08 w=4e-07 ad=4e-14 as=4e-14 \
 pd=6e-07 ps=6e-07 nrd=0 nrs=0 sa=1.98e-06 sb=1.46e-06 sca=0.602605 \
 scb=2.67635e-06 scc=7.14388e-12
mXI4\/XI13\/MNM9 ( N_XI4\/XI13\/NET21_XI4\/XI13\/MNM9_d \
 N_XI4\/NET22_XI4\/XI13\/MNM9_g N_GND_XI4\/XI13\/MNM9_s \
 N_GND_XI4\/XI18\/MNM6_b ) N_12_LLRVT l=6e-08 w=4e-07 ad=4e-14 as=4e-14 \
 pd=6e-07 ps=6e-07 nrd=0 nrs=0 sa=1.98e-06 sb=1.46e-06 sca=0.602605 \
 scb=2.67635e-06 scc=7.14388e-12
mXI4\/XI14\/MNM9 ( N_XI4\/XI14\/NET21_XI4\/XI14\/MNM9_d \
 N_XI4\/NET24_XI4\/XI14\/MNM9_g N_GND_XI4\/XI14\/MNM9_s \
 N_GND_XI4\/XI18\/MNM6_b ) N_12_LLRVT l=6e-08 w=4e-07 ad=4e-14 as=4e-14 \
 pd=6e-07 ps=6e-07 nrd=0 nrs=0 sa=1.98e-06 sb=1.46e-06 sca=0.602605 \
 scb=2.67635e-06 scc=7.14388e-12
mXI4\/XI19\/MNM9 ( N_XI4\/XI19\/NET252_XI4\/XI19\/MNM9_d \
 N_XI4\/NET26_XI4\/XI19\/MNM9_g N_GND_XI4\/XI19\/MNM9_s \
 N_GND_XI4\/XI18\/MNM6_b ) N_12_LLRVT l=6e-08 w=4e-07 ad=4e-14 as=4e-14 \
 pd=6e-07 ps=6e-07 nrd=0 nrs=0 sa=1.98e-06 sb=1.46e-06 sca=0.602605 \
 scb=2.67635e-06 scc=7.14388e-12
mXI4\/XI9\/MPM23 ( N_XI4\/XI9\/NET015_XI4\/XI9\/MPM23_d \
 N_B\<1\>_XI4\/XI9\/MPM23_g N_VDD_XI4\/XI9\/MPM23_s N_VDD_XI4\/XI18\/MPM0_b ) \
 P_12_LLRVT l=6e-08 w=8e-07 ad=8e-14 as=8e-14 pd=1e-06 ps=1e-06 nrd=0 nrs=0 \
 sa=1.72e-06 sb=1.72e-06 sca=33.8408 scb=0.0231782 scc=0.0035407
mXI4\/XI10\/MPM23 ( N_XI4\/XI10\/NET015_XI4\/XI10\/MPM23_d \
 N_B\<2\>_XI4\/XI10\/MPM23_g N_VDD_XI4\/XI10\/MPM23_s N_VDD_XI4\/XI18\/MPM0_b \
 ) P_12_LLRVT l=6e-08 w=8e-07 ad=8e-14 as=8e-14 pd=1e-06 ps=1e-06 nrd=0 nrs=0 \
 sa=1.72e-06 sb=1.72e-06 sca=33.8408 scb=0.0231782 scc=0.0035407
mXI4\/XI11\/MPM23 ( N_XI4\/XI11\/NET015_XI4\/XI11\/MPM23_d \
 N_B\<3\>_XI4\/XI11\/MPM23_g N_VDD_XI4\/XI11\/MPM23_s N_VDD_XI4\/XI18\/MPM0_b \
 ) P_12_LLRVT l=6e-08 w=8e-07 ad=8e-14 as=8e-14 pd=1e-06 ps=1e-06 nrd=0 nrs=0 \
 sa=1.72e-06 sb=1.72e-06 sca=33.8408 scb=0.0231782 scc=0.0035407
mXI4\/XI12\/MPM23 ( N_XI4\/XI12\/NET015_XI4\/XI12\/MPM23_d \
 N_B\<4\>_XI4\/XI12\/MPM23_g N_VDD_XI4\/XI12\/MPM23_s N_VDD_XI4\/XI18\/MPM0_b \
 ) P_12_LLRVT l=6e-08 w=8e-07 ad=8e-14 as=8e-14 pd=1e-06 ps=1e-06 nrd=0 nrs=0 \
 sa=1.72e-06 sb=1.72e-06 sca=33.8408 scb=0.0231782 scc=0.0035407
mXI4\/XI13\/MPM23 ( N_XI4\/XI13\/NET015_XI4\/XI13\/MPM23_d \
 N_B\<5\>_XI4\/XI13\/MPM23_g N_VDD_XI4\/XI13\/MPM23_s N_VDD_XI4\/XI18\/MPM0_b \
 ) P_12_LLRVT l=6e-08 w=8e-07 ad=8e-14 as=8e-14 pd=1e-06 ps=1e-06 nrd=0 nrs=0 \
 sa=1.72e-06 sb=1.72e-06 sca=33.8408 scb=0.0231782 scc=0.0035407
mXI4\/XI14\/MPM23 ( N_XI4\/XI14\/NET015_XI4\/XI14\/MPM23_d \
 N_B\<6\>_XI4\/XI14\/MPM23_g N_VDD_XI4\/XI14\/MPM23_s N_VDD_XI4\/XI18\/MPM0_b \
 ) P_12_LLRVT l=6e-08 w=8e-07 ad=8e-14 as=8e-14 pd=1e-06 ps=1e-06 nrd=0 nrs=0 \
 sa=1.72e-06 sb=1.72e-06 sca=33.8408 scb=0.0231782 scc=0.0035407
mXI4\/XI19\/MPM23 ( N_XI4\/XI19\/NET253_XI4\/XI19\/MPM23_d \
 N_B\<7\>_XI4\/XI19\/MPM23_g N_VDD_XI4\/XI19\/MPM23_s N_VDD_XI4\/XI18\/MPM0_b \
 ) P_12_LLRVT l=6e-08 w=8e-07 ad=8e-14 as=8e-14 pd=1e-06 ps=1e-06 nrd=0 nrs=0 \
 sa=1.72e-06 sb=1.72e-06 sca=33.8408 scb=0.0231782 scc=0.0035407
mXI4\/XI9\/MNM8 ( N_XI4\/XI9\/NET21_XI4\/XI9\/MNM8_d N_B\<1\>_XI4\/XI9\/MNM8_g \
 N_GND_XI4\/XI9\/MNM8_s N_GND_XI4\/XI18\/MNM6_b ) N_12_LLRVT l=6e-08 w=4e-07 \
 ad=4e-14 as=4e-14 pd=6e-07 ps=6e-07 nrd=0 nrs=0 sa=1.72e-06 sb=1.72e-06 \
 sca=0.602605 scb=2.67635e-06 scc=7.14388e-12
mXI4\/XI10\/MNM8 ( N_XI4\/XI10\/NET21_XI4\/XI10\/MNM8_d \
 N_B\<2\>_XI4\/XI10\/MNM8_g N_GND_XI4\/XI10\/MNM8_s N_GND_XI4\/XI18\/MNM6_b ) \
 N_12_LLRVT l=6e-08 w=4e-07 ad=4e-14 as=4e-14 pd=6e-07 ps=6e-07 nrd=0 nrs=0 \
 sa=1.72e-06 sb=1.72e-06 sca=0.602605 scb=2.67635e-06 scc=7.14388e-12
mXI4\/XI11\/MNM8 ( N_XI4\/XI11\/NET21_XI4\/XI11\/MNM8_d \
 N_B\<3\>_XI4\/XI11\/MNM8_g N_GND_XI4\/XI11\/MNM8_s N_GND_XI4\/XI18\/MNM6_b ) \
 N_12_LLRVT l=6e-08 w=4e-07 ad=4e-14 as=4e-14 pd=6e-07 ps=6e-07 nrd=0 nrs=0 \
 sa=1.72e-06 sb=1.72e-06 sca=0.602605 scb=2.67635e-06 scc=7.14388e-12
mXI4\/XI12\/MNM8 ( N_XI4\/XI12\/NET21_XI4\/XI12\/MNM8_d \
 N_B\<4\>_XI4\/XI12\/MNM8_g N_GND_XI4\/XI12\/MNM8_s N_GND_XI4\/XI18\/MNM6_b ) \
 N_12_LLRVT l=6e-08 w=4e-07 ad=4e-14 as=4e-14 pd=6e-07 ps=6e-07 nrd=0 nrs=0 \
 sa=1.72e-06 sb=1.72e-06 sca=0.602605 scb=2.67635e-06 scc=7.14388e-12
mXI4\/XI13\/MNM8 ( N_XI4\/XI13\/NET21_XI4\/XI13\/MNM8_d \
 N_B\<5\>_XI4\/XI13\/MNM8_g N_GND_XI4\/XI13\/MNM8_s N_GND_XI4\/XI18\/MNM6_b ) \
 N_12_LLRVT l=6e-08 w=4e-07 ad=4e-14 as=4e-14 pd=6e-07 ps=6e-07 nrd=0 nrs=0 \
 sa=1.72e-06 sb=1.72e-06 sca=0.602605 scb=2.67635e-06 scc=7.14388e-12
mXI4\/XI14\/MNM8 ( N_XI4\/XI14\/NET21_XI4\/XI14\/MNM8_d \
 N_B\<6\>_XI4\/XI14\/MNM8_g N_GND_XI4\/XI14\/MNM8_s N_GND_XI4\/XI18\/MNM6_b ) \
 N_12_LLRVT l=6e-08 w=4e-07 ad=4e-14 as=4e-14 pd=6e-07 ps=6e-07 nrd=0 nrs=0 \
 sa=1.72e-06 sb=1.72e-06 sca=0.602605 scb=2.67635e-06 scc=7.14388e-12
mXI4\/XI19\/MNM8 ( N_XI4\/XI19\/NET252_XI4\/XI19\/MNM8_d \
 N_B\<7\>_XI4\/XI19\/MNM8_g N_GND_XI4\/XI19\/MNM8_s N_GND_XI4\/XI18\/MNM6_b ) \
 N_12_LLRVT l=6e-08 w=4e-07 ad=4e-14 as=4e-14 pd=6e-07 ps=6e-07 nrd=0 nrs=0 \
 sa=1.72e-06 sb=1.72e-06 sca=0.602605 scb=2.67635e-06 scc=7.14388e-12
mXI4\/XI9\/MPM22 ( N_XI4\/XI9\/NET015_XI4\/XI9\/MPM22_d \
 N_A\<1\>_XI4\/XI9\/MPM22_g N_VDD_XI4\/XI9\/MPM22_s N_VDD_XI4\/XI18\/MPM0_b ) \
 P_12_LLRVT l=6e-08 w=8e-07 ad=8e-14 as=8e-14 pd=1e-06 ps=1e-06 nrd=0 nrs=0 \
 sa=1.46e-06 sb=1.98e-06 sca=34.1152 scb=0.0233305 scc=0.00354076
mXI4\/XI10\/MPM22 ( N_XI4\/XI10\/NET015_XI4\/XI10\/MPM22_d \
 N_A\<2\>_XI4\/XI10\/MPM22_g N_VDD_XI4\/XI10\/MPM22_s N_VDD_XI4\/XI18\/MPM0_b \
 ) P_12_LLRVT l=6e-08 w=8e-07 ad=8e-14 as=8e-14 pd=1e-06 ps=1e-06 nrd=0 nrs=0 \
 sa=1.46e-06 sb=1.98e-06 sca=34.1152 scb=0.0233305 scc=0.00354076
mXI4\/XI11\/MPM22 ( N_XI4\/XI11\/NET015_XI4\/XI11\/MPM22_d \
 N_A\<3\>_XI4\/XI11\/MPM22_g N_VDD_XI4\/XI11\/MPM22_s N_VDD_XI4\/XI18\/MPM0_b \
 ) P_12_LLRVT l=6e-08 w=8e-07 ad=8e-14 as=8e-14 pd=1e-06 ps=1e-06 nrd=0 nrs=0 \
 sa=1.46e-06 sb=1.98e-06 sca=34.1152 scb=0.0233305 scc=0.00354076
mXI4\/XI12\/MPM22 ( N_XI4\/XI12\/NET015_XI4\/XI12\/MPM22_d \
 N_A\<4\>_XI4\/XI12\/MPM22_g N_VDD_XI4\/XI12\/MPM22_s N_VDD_XI4\/XI18\/MPM0_b \
 ) P_12_LLRVT l=6e-08 w=8e-07 ad=8e-14 as=8e-14 pd=1e-06 ps=1e-06 nrd=0 nrs=0 \
 sa=1.46e-06 sb=1.98e-06 sca=34.1152 scb=0.0233305 scc=0.00354076
mXI4\/XI13\/MPM22 ( N_XI4\/XI13\/NET015_XI4\/XI13\/MPM22_d \
 N_A\<5\>_XI4\/XI13\/MPM22_g N_VDD_XI4\/XI13\/MPM22_s N_VDD_XI4\/XI18\/MPM0_b \
 ) P_12_LLRVT l=6e-08 w=8e-07 ad=8e-14 as=8e-14 pd=1e-06 ps=1e-06 nrd=0 nrs=0 \
 sa=1.46e-06 sb=1.98e-06 sca=34.1152 scb=0.0233305 scc=0.00354076
mXI4\/XI14\/MPM22 ( N_XI4\/XI14\/NET015_XI4\/XI14\/MPM22_d \
 N_A\<6\>_XI4\/XI14\/MPM22_g N_VDD_XI4\/XI14\/MPM22_s N_VDD_XI4\/XI18\/MPM0_b \
 ) P_12_LLRVT l=6e-08 w=8e-07 ad=8e-14 as=8e-14 pd=1e-06 ps=1e-06 nrd=0 nrs=0 \
 sa=1.46e-06 sb=1.98e-06 sca=34.1152 scb=0.0233305 scc=0.00354076
mXI4\/XI19\/MPM22 ( N_XI4\/XI19\/NET253_XI4\/XI19\/MPM22_d \
 N_A\<7\>_XI4\/XI19\/MPM22_g N_VDD_XI4\/XI19\/MPM22_s N_VDD_XI4\/XI18\/MPM0_b \
 ) P_12_LLRVT l=6e-08 w=8e-07 ad=8e-14 as=8e-14 pd=1e-06 ps=1e-06 nrd=0 nrs=0 \
 sa=1.46e-06 sb=1.98e-06 sca=34.1152 scb=0.0233305 scc=0.00354076
mXI4\/XI9\/MNM7 ( N_XI4\/XI9\/NET21_XI4\/XI9\/MNM7_d N_A\<1\>_XI4\/XI9\/MNM7_g \
 N_GND_XI4\/XI9\/MNM7_s N_GND_XI4\/XI18\/MNM6_b ) N_12_LLRVT l=6e-08 w=4e-07 \
 ad=4e-14 as=4e-14 pd=6e-07 ps=6e-07 nrd=0 nrs=0 sa=1.46e-06 sb=1.98e-06 \
 sca=0.602605 scb=2.67635e-06 scc=7.14388e-12
mXI4\/XI10\/MNM7 ( N_XI4\/XI10\/NET21_XI4\/XI10\/MNM7_d \
 N_A\<2\>_XI4\/XI10\/MNM7_g N_GND_XI4\/XI10\/MNM7_s N_GND_XI4\/XI18\/MNM6_b ) \
 N_12_LLRVT l=6e-08 w=4e-07 ad=4e-14 as=4e-14 pd=6e-07 ps=6e-07 nrd=0 nrs=0 \
 sa=1.46e-06 sb=1.98e-06 sca=0.602605 scb=2.67635e-06 scc=7.14388e-12
mXI4\/XI11\/MNM7 ( N_XI4\/XI11\/NET21_XI4\/XI11\/MNM7_d \
 N_A\<3\>_XI4\/XI11\/MNM7_g N_GND_XI4\/XI11\/MNM7_s N_GND_XI4\/XI18\/MNM6_b ) \
 N_12_LLRVT l=6e-08 w=4e-07 ad=4e-14 as=4e-14 pd=6e-07 ps=6e-07 nrd=0 nrs=0 \
 sa=1.46e-06 sb=1.98e-06 sca=0.602605 scb=2.67635e-06 scc=7.14388e-12
mXI4\/XI12\/MNM7 ( N_XI4\/XI12\/NET21_XI4\/XI12\/MNM7_d \
 N_A\<4\>_XI4\/XI12\/MNM7_g N_GND_XI4\/XI12\/MNM7_s N_GND_XI4\/XI18\/MNM6_b ) \
 N_12_LLRVT l=6e-08 w=4e-07 ad=4e-14 as=4e-14 pd=6e-07 ps=6e-07 nrd=0 nrs=0 \
 sa=1.46e-06 sb=1.98e-06 sca=0.602605 scb=2.67635e-06 scc=7.14388e-12
mXI4\/XI13\/MNM7 ( N_XI4\/XI13\/NET21_XI4\/XI13\/MNM7_d \
 N_A\<5\>_XI4\/XI13\/MNM7_g N_GND_XI4\/XI13\/MNM7_s N_GND_XI4\/XI18\/MNM6_b ) \
 N_12_LLRVT l=6e-08 w=4e-07 ad=4e-14 as=4e-14 pd=6e-07 ps=6e-07 nrd=0 nrs=0 \
 sa=1.46e-06 sb=1.98e-06 sca=0.602605 scb=2.67635e-06 scc=7.14388e-12
mXI4\/XI14\/MNM7 ( N_XI4\/XI14\/NET21_XI4\/XI14\/MNM7_d \
 N_A\<6\>_XI4\/XI14\/MNM7_g N_GND_XI4\/XI14\/MNM7_s N_GND_XI4\/XI18\/MNM6_b ) \
 N_12_LLRVT l=6e-08 w=4e-07 ad=4e-14 as=4e-14 pd=6e-07 ps=6e-07 nrd=0 nrs=0 \
 sa=1.46e-06 sb=1.98e-06 sca=0.602605 scb=2.67635e-06 scc=7.14388e-12
mXI4\/XI19\/MNM7 ( N_XI4\/XI19\/NET252_XI4\/XI19\/MNM7_d \
 N_A\<7\>_XI4\/XI19\/MNM7_g N_GND_XI4\/XI19\/MNM7_s N_GND_XI4\/XI18\/MNM6_b ) \
 N_12_LLRVT l=6e-08 w=4e-07 ad=4e-14 as=4e-14 pd=6e-07 ps=6e-07 nrd=0 nrs=0 \
 sa=1.46e-06 sb=1.98e-06 sca=0.602605 scb=2.67635e-06 scc=7.14388e-12
mXI4\/XI9\/MPM29 ( N_XI4\/XI9\/NET033_XI4\/XI9\/MPM29_d \
 N_B\<1\>_XI4\/XI9\/MPM29_g N_VDD_XI4\/XI9\/MPM29_s N_VDD_XI4\/XI18\/MPM0_b ) \
 P_12_LLRVT l=6e-08 w=8e-07 ad=8e-14 as=8e-14 pd=1e-06 ps=1e-06 nrd=0 nrs=0 \
 sa=1.2e-06 sb=2.24e-06 sca=34.6492 scb=0.0238012 scc=0.0035414
mXI4\/XI10\/MPM29 ( N_XI4\/XI10\/NET033_XI4\/XI10\/MPM29_d \
 N_B\<2\>_XI4\/XI10\/MPM29_g N_VDD_XI4\/XI10\/MPM29_s N_VDD_XI4\/XI18\/MPM0_b \
 ) P_12_LLRVT l=6e-08 w=8e-07 ad=8e-14 as=8e-14 pd=1e-06 ps=1e-06 nrd=0 nrs=0 \
 sa=1.2e-06 sb=2.24e-06 sca=34.6492 scb=0.0238012 scc=0.0035414
mXI4\/XI11\/MPM29 ( N_XI4\/XI11\/NET033_XI4\/XI11\/MPM29_d \
 N_B\<3\>_XI4\/XI11\/MPM29_g N_VDD_XI4\/XI11\/MPM29_s N_VDD_XI4\/XI18\/MPM0_b \
 ) P_12_LLRVT l=6e-08 w=8e-07 ad=8e-14 as=8e-14 pd=1e-06 ps=1e-06 nrd=0 nrs=0 \
 sa=1.2e-06 sb=2.24e-06 sca=34.6492 scb=0.0238012 scc=0.0035414
mXI4\/XI12\/MPM29 ( N_XI4\/XI12\/NET033_XI4\/XI12\/MPM29_d \
 N_B\<4\>_XI4\/XI12\/MPM29_g N_VDD_XI4\/XI12\/MPM29_s N_VDD_XI4\/XI18\/MPM0_b \
 ) P_12_LLRVT l=6e-08 w=8e-07 ad=8e-14 as=8e-14 pd=1e-06 ps=1e-06 nrd=0 nrs=0 \
 sa=1.2e-06 sb=2.24e-06 sca=34.6492 scb=0.0238012 scc=0.0035414
mXI4\/XI13\/MPM29 ( N_XI4\/XI13\/NET033_XI4\/XI13\/MPM29_d \
 N_B\<5\>_XI4\/XI13\/MPM29_g N_VDD_XI4\/XI13\/MPM29_s N_VDD_XI4\/XI18\/MPM0_b \
 ) P_12_LLRVT l=6e-08 w=8e-07 ad=8e-14 as=8e-14 pd=1e-06 ps=1e-06 nrd=0 nrs=0 \
 sa=1.2e-06 sb=2.24e-06 sca=34.6492 scb=0.0238012 scc=0.0035414
mXI4\/XI14\/MPM29 ( N_XI4\/XI14\/NET033_XI4\/XI14\/MPM29_d \
 N_B\<6\>_XI4\/XI14\/MPM29_g N_VDD_XI4\/XI14\/MPM29_s N_VDD_XI4\/XI18\/MPM0_b \
 ) P_12_LLRVT l=6e-08 w=8e-07 ad=8e-14 as=8e-14 pd=1e-06 ps=1e-06 nrd=0 nrs=0 \
 sa=1.2e-06 sb=2.24e-06 sca=34.6492 scb=0.0238012 scc=0.0035414
mXI4\/XI19\/MPM29 ( N_XI4\/XI19\/NET259_XI4\/XI19\/MPM29_d \
 N_B\<7\>_XI4\/XI19\/MPM29_g N_VDD_XI4\/XI19\/MPM29_s N_VDD_XI4\/XI18\/MPM0_b \
 ) P_12_LLRVT l=6e-08 w=8e-07 ad=8e-14 as=8e-14 pd=1e-06 ps=1e-06 nrd=0 nrs=0 \
 sa=1.2e-06 sb=2.24e-06 sca=34.6492 scb=0.0238012 scc=0.0035414
mXI4\/XI9\/MNM1 ( N_XI4\/XI9\/NET51_XI4\/XI9\/MNM1_d N_A\<1\>_XI4\/XI9\/MNM1_g \
 N_GND_XI4\/XI9\/MNM1_s N_GND_XI4\/XI18\/MNM6_b ) N_12_LLRVT l=6e-08 w=4e-07 \
 ad=4e-14 as=4e-14 pd=6e-07 ps=6e-07 nrd=0 nrs=0 sa=4.2e-07 sb=3.02e-06 \
 sca=0.602605 scb=2.67635e-06 scc=7.14388e-12
mXI4\/XI10\/MNM1 ( N_XI4\/XI10\/NET51_XI4\/XI10\/MNM1_d \
 N_A\<2\>_XI4\/XI10\/MNM1_g N_GND_XI4\/XI10\/MNM1_s N_GND_XI4\/XI18\/MNM6_b ) \
 N_12_LLRVT l=6e-08 w=4e-07 ad=4e-14 as=4e-14 pd=6e-07 ps=6e-07 nrd=0 nrs=0 \
 sa=4.2e-07 sb=3.02e-06 sca=0.602605 scb=2.67635e-06 scc=7.14388e-12
mXI4\/XI11\/MNM1 ( N_XI4\/XI11\/NET51_XI4\/XI11\/MNM1_d \
 N_A\<3\>_XI4\/XI11\/MNM1_g N_GND_XI4\/XI11\/MNM1_s N_GND_XI4\/XI18\/MNM6_b ) \
 N_12_LLRVT l=6e-08 w=4e-07 ad=4e-14 as=4e-14 pd=6e-07 ps=6e-07 nrd=0 nrs=0 \
 sa=4.2e-07 sb=3.02e-06 sca=0.602605 scb=2.67635e-06 scc=7.14388e-12
mXI4\/XI12\/MNM1 ( N_XI4\/XI12\/NET51_XI4\/XI12\/MNM1_d \
 N_A\<4\>_XI4\/XI12\/MNM1_g N_GND_XI4\/XI12\/MNM1_s N_GND_XI4\/XI18\/MNM6_b ) \
 N_12_LLRVT l=6e-08 w=4e-07 ad=4e-14 as=4e-14 pd=6e-07 ps=6e-07 nrd=0 nrs=0 \
 sa=4.2e-07 sb=3.02e-06 sca=0.602605 scb=2.67635e-06 scc=7.14388e-12
mXI4\/XI13\/MNM1 ( N_XI4\/XI13\/NET51_XI4\/XI13\/MNM1_d \
 N_A\<5\>_XI4\/XI13\/MNM1_g N_GND_XI4\/XI13\/MNM1_s N_GND_XI4\/XI18\/MNM6_b ) \
 N_12_LLRVT l=6e-08 w=4e-07 ad=4e-14 as=4e-14 pd=6e-07 ps=6e-07 nrd=0 nrs=0 \
 sa=4.2e-07 sb=3.02e-06 sca=0.602605 scb=2.67635e-06 scc=7.14388e-12
mXI4\/XI14\/MNM1 ( N_XI4\/XI14\/NET51_XI4\/XI14\/MNM1_d \
 N_A\<6\>_XI4\/XI14\/MNM1_g N_GND_XI4\/XI14\/MNM1_s N_GND_XI4\/XI18\/MNM6_b ) \
 N_12_LLRVT l=6e-08 w=4e-07 ad=4e-14 as=4e-14 pd=6e-07 ps=6e-07 nrd=0 nrs=0 \
 sa=4.2e-07 sb=3.02e-06 sca=0.602605 scb=2.67635e-06 scc=7.14388e-12
mXI4\/XI19\/MNM1 ( N_XI4\/XI19\/NET246_XI4\/XI19\/MNM1_d \
 N_A\<7\>_XI4\/XI19\/MNM1_g N_GND_XI4\/XI19\/MNM1_s N_GND_XI4\/XI18\/MNM6_b ) \
 N_12_LLRVT l=6e-08 w=4e-07 ad=4e-14 as=4e-14 pd=6e-07 ps=6e-07 nrd=0 nrs=0 \
 sa=4.2e-07 sb=3.02e-06 sca=0.602605 scb=2.67635e-06 scc=7.14388e-12
mXI4\/XI18\/MPM17 ( N_XI4\/XI18\/NET247_XI4\/XI18\/MPM17_d \
 N_A\<0\>_XI4\/XI18\/MPM17_g N_VDD_XI4\/XI18\/MPM17_s N_VDD_XI4\/XI18\/MPM0_b \
 ) P_12_LLRVT l=6e-08 w=8e-07 ad=8e-14 as=8e-14 pd=1e-06 ps=1e-06 nrd=0 nrs=0 \
 sa=4.2e-07 sb=3.02e-06 sca=43.5362 scb=0.0380584 scc=0.00429177
mXI4\/XI18\/MPM18 ( N_XI4\/XI18\/NET247_XI4\/XI18\/MPM18_d \
 N_B\<0\>_XI4\/XI18\/MPM18_g N_VDD_XI4\/XI18\/MPM18_s N_VDD_XI4\/XI18\/MPM0_b \
 ) P_12_LLRVT l=6e-08 w=8e-07 ad=1.28e-13 as=8e-14 pd=1.92e-06 ps=1e-06 nrd=0 \
 nrs=0 sa=1.6e-07 sb=3.28e-06 sca=67.2385 scb=0.0541391 scc=0.00924912
mXI4\/XI9\/MPM17 ( N_XI4\/XI9\/NET06_XI4\/XI9\/MPM17_d \
 N_A\<1\>_XI4\/XI9\/MPM17_g N_VDD_XI4\/XI9\/MPM17_s N_VDD_XI4\/XI18\/MPM0_b ) \
 P_12_LLRVT l=6e-08 w=8e-07 ad=8e-14 as=8e-14 pd=1e-06 ps=1e-06 nrd=0 nrs=0 \
 sa=4.2e-07 sb=3.02e-06 sca=43.5362 scb=0.0380584 scc=0.00429177
mXI4\/XI9\/MPM18 ( N_XI4\/XI9\/NET06_XI4\/XI9\/MPM18_d \
 N_B\<1\>_XI4\/XI9\/MPM18_g N_VDD_XI4\/XI9\/MPM18_s N_VDD_XI4\/XI18\/MPM0_b ) \
 P_12_LLRVT l=6e-08 w=8e-07 ad=1.28e-13 as=8e-14 pd=1.92e-06 ps=1e-06 nrd=0 \
 nrs=0 sa=1.6e-07 sb=3.28e-06 sca=67.2385 scb=0.0541391 scc=0.00924912
mXI4\/XI10\/MPM17 ( N_XI4\/XI10\/NET06_XI4\/XI10\/MPM17_d \
 N_A\<2\>_XI4\/XI10\/MPM17_g N_VDD_XI4\/XI10\/MPM17_s N_VDD_XI4\/XI18\/MPM0_b \
 ) P_12_LLRVT l=6e-08 w=8e-07 ad=8e-14 as=8e-14 pd=1e-06 ps=1e-06 nrd=0 nrs=0 \
 sa=4.2e-07 sb=3.02e-06 sca=43.5362 scb=0.0380584 scc=0.00429177
mXI4\/XI10\/MPM18 ( N_XI4\/XI10\/NET06_XI4\/XI10\/MPM18_d \
 N_B\<2\>_XI4\/XI10\/MPM18_g N_VDD_XI4\/XI10\/MPM18_s N_VDD_XI4\/XI18\/MPM0_b \
 ) P_12_LLRVT l=6e-08 w=8e-07 ad=1.28e-13 as=8e-14 pd=1.92e-06 ps=1e-06 nrd=0 \
 nrs=0 sa=1.6e-07 sb=3.28e-06 sca=67.2385 scb=0.0541391 scc=0.00924912
mXI4\/XI11\/MPM17 ( N_XI4\/XI11\/NET06_XI4\/XI11\/MPM17_d \
 N_A\<3\>_XI4\/XI11\/MPM17_g N_VDD_XI4\/XI11\/MPM17_s N_VDD_XI4\/XI18\/MPM0_b \
 ) P_12_LLRVT l=6e-08 w=8e-07 ad=8e-14 as=8e-14 pd=1e-06 ps=1e-06 nrd=0 nrs=0 \
 sa=4.2e-07 sb=3.02e-06 sca=43.5362 scb=0.0380584 scc=0.00429177
mXI4\/XI11\/MPM18 ( N_XI4\/XI11\/NET06_XI4\/XI11\/MPM18_d \
 N_B\<3\>_XI4\/XI11\/MPM18_g N_VDD_XI4\/XI11\/MPM18_s N_VDD_XI4\/XI18\/MPM0_b \
 ) P_12_LLRVT l=6e-08 w=8e-07 ad=1.28e-13 as=8e-14 pd=1.92e-06 ps=1e-06 nrd=0 \
 nrs=0 sa=1.6e-07 sb=3.28e-06 sca=67.2385 scb=0.0541391 scc=0.00924912
mXI4\/XI12\/MPM17 ( N_XI4\/XI12\/NET06_XI4\/XI12\/MPM17_d \
 N_A\<4\>_XI4\/XI12\/MPM17_g N_VDD_XI4\/XI12\/MPM17_s N_VDD_XI4\/XI18\/MPM0_b \
 ) P_12_LLRVT l=6e-08 w=8e-07 ad=8e-14 as=8e-14 pd=1e-06 ps=1e-06 nrd=0 nrs=0 \
 sa=4.2e-07 sb=3.02e-06 sca=43.5362 scb=0.0380584 scc=0.00429177
mXI4\/XI12\/MPM18 ( N_XI4\/XI12\/NET06_XI4\/XI12\/MPM18_d \
 N_B\<4\>_XI4\/XI12\/MPM18_g N_VDD_XI4\/XI12\/MPM18_s N_VDD_XI4\/XI18\/MPM0_b \
 ) P_12_LLRVT l=6e-08 w=8e-07 ad=1.28e-13 as=8e-14 pd=1.92e-06 ps=1e-06 nrd=0 \
 nrs=0 sa=1.6e-07 sb=3.28e-06 sca=67.2385 scb=0.0541391 scc=0.00924912
mXI4\/XI13\/MPM17 ( N_XI4\/XI13\/NET06_XI4\/XI13\/MPM17_d \
 N_A\<5\>_XI4\/XI13\/MPM17_g N_VDD_XI4\/XI13\/MPM17_s N_VDD_XI4\/XI18\/MPM0_b \
 ) P_12_LLRVT l=6e-08 w=8e-07 ad=8e-14 as=8e-14 pd=1e-06 ps=1e-06 nrd=0 nrs=0 \
 sa=4.2e-07 sb=3.02e-06 sca=43.5362 scb=0.0380584 scc=0.00429177
mXI4\/XI13\/MPM18 ( N_XI4\/XI13\/NET06_XI4\/XI13\/MPM18_d \
 N_B\<5\>_XI4\/XI13\/MPM18_g N_VDD_XI4\/XI13\/MPM18_s N_VDD_XI4\/XI18\/MPM0_b \
 ) P_12_LLRVT l=6e-08 w=8e-07 ad=1.28e-13 as=8e-14 pd=1.92e-06 ps=1e-06 nrd=0 \
 nrs=0 sa=1.6e-07 sb=3.28e-06 sca=67.2385 scb=0.0541391 scc=0.00924912
mXI4\/XI14\/MPM17 ( N_XI4\/XI14\/NET06_XI4\/XI14\/MPM17_d \
 N_A\<6\>_XI4\/XI14\/MPM17_g N_VDD_XI4\/XI14\/MPM17_s N_VDD_XI4\/XI18\/MPM0_b \
 ) P_12_LLRVT l=6e-08 w=8e-07 ad=8e-14 as=8e-14 pd=1e-06 ps=1e-06 nrd=0 nrs=0 \
 sa=4.2e-07 sb=3.02e-06 sca=43.5362 scb=0.0380584 scc=0.00429177
mXI4\/XI14\/MPM18 ( N_XI4\/XI14\/NET06_XI4\/XI14\/MPM18_d \
 N_B\<6\>_XI4\/XI14\/MPM18_g N_VDD_XI4\/XI14\/MPM18_s N_VDD_XI4\/XI18\/MPM0_b \
 ) P_12_LLRVT l=6e-08 w=8e-07 ad=1.28e-13 as=8e-14 pd=1.92e-06 ps=1e-06 nrd=0 \
 nrs=0 sa=1.6e-07 sb=3.28e-06 sca=67.2385 scb=0.0541391 scc=0.00924912
mXI4\/XI19\/MPM17 ( N_XI4\/XI19\/NET247_XI4\/XI19\/MPM17_d \
 N_A\<7\>_XI4\/XI19\/MPM17_g N_VDD_XI4\/XI19\/MPM17_s N_VDD_XI4\/XI18\/MPM0_b \
 ) P_12_LLRVT l=6e-08 w=8e-07 ad=8e-14 as=8e-14 pd=1e-06 ps=1e-06 nrd=0 nrs=0 \
 sa=4.2e-07 sb=3.02e-06 sca=43.5362 scb=0.0380584 scc=0.00429177
mXI4\/XI19\/MPM18 ( N_XI4\/XI19\/NET247_XI4\/XI19\/MPM18_d \
 N_B\<7\>_XI4\/XI19\/MPM18_g N_VDD_XI4\/XI19\/MPM18_s N_VDD_XI4\/XI18\/MPM0_b \
 ) P_12_LLRVT l=6e-08 w=8e-07 ad=1.28e-13 as=8e-14 pd=1.92e-06 ps=1e-06 nrd=0 \
 nrs=0 sa=1.6e-07 sb=3.28e-06 sca=67.2385 scb=0.0541391 scc=0.00924912
mXI4\/XI18\/MNM2 ( N_XI4\/XI18\/NET246_XI4\/XI18\/MNM2_d \
 N_B\<0\>_XI4\/XI18\/MNM2_g N_GND_XI4\/XI18\/MNM2_s N_GND_XI4\/XI18\/MNM6_b ) \
 N_12_LLRVT l=6e-08 w=4e-07 ad=6.4e-14 as=4e-14 pd=1.12e-06 ps=6e-07 nrd=0 \
 nrs=0 sa=1.6e-07 sb=3.28e-06 sca=0.602605 scb=2.67635e-06 scc=7.14388e-12
mXI4\/XI9\/MNM2 ( N_XI4\/XI9\/NET51_XI4\/XI9\/MNM2_d N_B\<1\>_XI4\/XI9\/MNM2_g \
 N_GND_XI4\/XI9\/MNM2_s N_GND_XI4\/XI18\/MNM6_b ) N_12_LLRVT l=6e-08 w=4e-07 \
 ad=6.4e-14 as=4e-14 pd=1.12e-06 ps=6e-07 nrd=0 nrs=0 sa=1.6e-07 sb=3.28e-06 \
 sca=0.602605 scb=2.67635e-06 scc=7.14388e-12
mXI4\/XI10\/MNM2 ( N_XI4\/XI10\/NET51_XI4\/XI10\/MNM2_d \
 N_B\<2\>_XI4\/XI10\/MNM2_g N_GND_XI4\/XI10\/MNM2_s N_GND_XI4\/XI18\/MNM6_b ) \
 N_12_LLRVT l=6e-08 w=4e-07 ad=6.4e-14 as=4e-14 pd=1.12e-06 ps=6e-07 nrd=0 \
 nrs=0 sa=1.6e-07 sb=3.28e-06 sca=0.602605 scb=2.67635e-06 scc=7.14388e-12
mXI4\/XI11\/MNM2 ( N_XI4\/XI11\/NET51_XI4\/XI11\/MNM2_d \
 N_B\<3\>_XI4\/XI11\/MNM2_g N_GND_XI4\/XI11\/MNM2_s N_GND_XI4\/XI18\/MNM6_b ) \
 N_12_LLRVT l=6e-08 w=4e-07 ad=6.4e-14 as=4e-14 pd=1.12e-06 ps=6e-07 nrd=0 \
 nrs=0 sa=1.6e-07 sb=3.28e-06 sca=0.602605 scb=2.67635e-06 scc=7.14388e-12
mXI4\/XI12\/MNM2 ( N_XI4\/XI12\/NET51_XI4\/XI12\/MNM2_d \
 N_B\<4\>_XI4\/XI12\/MNM2_g N_GND_XI4\/XI12\/MNM2_s N_GND_XI4\/XI18\/MNM6_b ) \
 N_12_LLRVT l=6e-08 w=4e-07 ad=6.4e-14 as=4e-14 pd=1.12e-06 ps=6e-07 nrd=0 \
 nrs=0 sa=1.6e-07 sb=3.28e-06 sca=0.602605 scb=2.67635e-06 scc=7.14388e-12
mXI4\/XI13\/MNM2 ( N_XI4\/XI13\/NET51_XI4\/XI13\/MNM2_d \
 N_B\<5\>_XI4\/XI13\/MNM2_g N_GND_XI4\/XI13\/MNM2_s N_GND_XI4\/XI18\/MNM6_b ) \
 N_12_LLRVT l=6e-08 w=4e-07 ad=6.4e-14 as=4e-14 pd=1.12e-06 ps=6e-07 nrd=0 \
 nrs=0 sa=1.6e-07 sb=3.28e-06 sca=0.602605 scb=2.67635e-06 scc=7.14388e-12
mXI4\/XI14\/MNM2 ( N_XI4\/XI14\/NET51_XI4\/XI14\/MNM2_d \
 N_B\<6\>_XI4\/XI14\/MNM2_g N_GND_XI4\/XI14\/MNM2_s N_GND_XI4\/XI18\/MNM6_b ) \
 N_12_LLRVT l=6e-08 w=4e-07 ad=6.4e-14 as=4e-14 pd=1.12e-06 ps=6e-07 nrd=0 \
 nrs=0 sa=1.6e-07 sb=3.28e-06 sca=0.602605 scb=2.67635e-06 scc=7.14388e-12
mXI4\/XI19\/MNM2 ( N_XI4\/XI19\/NET246_XI4\/XI19\/MNM2_d \
 N_B\<7\>_XI4\/XI19\/MNM2_g N_GND_XI4\/XI19\/MNM2_s N_GND_XI4\/XI18\/MNM6_b ) \
 N_12_LLRVT l=6e-08 w=4e-07 ad=6.4e-14 as=4e-14 pd=1.12e-06 ps=6e-07 nrd=0 \
 nrs=0 sa=1.6e-07 sb=3.28e-06 sca=0.602605 scb=2.67635e-06 scc=7.14388e-12
mXI0\/XLOGIC\<0\>\/MNM2 ( N_noxref_78_XI0\/XLOGIC\<0\>\/MNM2_d \
 N_A\<0\>_XI0\/XLOGIC\<0\>\/MNM2_g N_GND_XI0\/XLOGIC\<0\>\/MNM2_s \
 N_GND_XI4\/XI18\/MNM6_b ) N_12_LLRVT l=6e-08 w=2e-07 ad=2e-14 as=2e-14 \
 pd=4e-07 ps=4e-07 nrd=0 nrs=0 sa=6.8e-07 sb=6.8e-07 sca=9.47831 \
 scb=0.00955185 scc=0.000184287
mXI0\/XLOGIC\<0\>\/MNM5 ( N_X\<0\>_XI0\/XLOGIC\<0\>\/MNM5_d \
 N_CTR\<1\>_XI0\/XLOGIC\<0\>\/MNM5_g N_noxref_78_XI0\/XLOGIC\<0\>\/MNM5_s \
 N_GND_XI4\/XI18\/MNM6_b ) N_12_LLRVT l=6e-08 w=2e-07 ad=2e-14 as=2e-14 \
 pd=4e-07 ps=4e-07 nrd=0 nrs=0 sa=4.2e-07 sb=9.4e-07 sca=9.47831 \
 scb=0.00955185 scc=0.000184287
mXI0\/XLOGIC\<0\>\/MNM0 ( N_X\<0\>_XI0\/XLOGIC\<0\>\/MNM0_d \
 N_B\<0\>_XI0\/XLOGIC\<0\>\/MNM0_g N_noxref_78_XI0\/XLOGIC\<0\>\/MNM0_s \
 N_GND_XI4\/XI18\/MNM6_b ) N_12_LLRVT l=6e-08 w=2e-07 ad=2e-14 as=3.2e-14 \
 pd=4e-07 ps=7.2e-07 nrd=0 nrs=0 sa=1.6e-07 sb=1.2e-06 sca=9.47831 \
 scb=0.00955185 scc=0.000184287
mXI0\/XLOGIC\<0\>\/MNM7 ( N_noxref_126_XI0\/XLOGIC\<0\>\/MNM7_d \
 N_CTR\<0\>_XI0\/XLOGIC\<0\>\/MNM7_g N_GND_XI0\/XLOGIC\<0\>\/MNM7_s \
 N_GND_XI4\/XI18\/MNM6_b ) N_12_LLRVT l=6e-08 w=2e-07 ad=2e-14 as=2e-14 \
 pd=4e-07 ps=4e-07 nrd=0 nrs=0 sa=9.4e-07 sb=4.2e-07 sca=9.47831 \
 scb=0.00955185 scc=0.000184287
mXI0\/XLOGIC\<0\>\/MNM6 ( N_noxref_78_XI0\/XLOGIC\<0\>\/MNM6_d \
 N_B\<0\>_XI0\/XLOGIC\<0\>\/MNM6_g N_noxref_126_XI0\/XLOGIC\<0\>\/MNM6_s \
 N_GND_XI4\/XI18\/MNM6_b ) N_12_LLRVT l=6e-08 w=2e-07 ad=3.2e-14 as=2e-14 \
 pd=7.2e-07 ps=4e-07 nrd=0 nrs=0 sa=1.2e-06 sb=1.6e-07 sca=9.47831 \
 scb=0.00955185 scc=0.000184287
mXI0\/XLOGIC\<1\>\/MNM2 ( N_noxref_84_XI0\/XLOGIC\<1\>\/MNM2_d \
 N_A\<1\>_XI0\/XLOGIC\<1\>\/MNM2_g N_GND_XI0\/XLOGIC\<1\>\/MNM2_s \
 N_GND_XI4\/XI18\/MNM6_b ) N_12_LLRVT l=6e-08 w=2e-07 ad=2e-14 as=2e-14 \
 pd=4e-07 ps=4e-07 nrd=0 nrs=0 sa=6.8e-07 sb=6.8e-07 sca=9.47831 \
 scb=0.00955185 scc=0.000184287
mXI0\/XLOGIC\<1\>\/MNM5 ( N_X\<1\>_XI0\/XLOGIC\<1\>\/MNM5_d \
 N_CTR\<1\>_XI0\/XLOGIC\<1\>\/MNM5_g N_noxref_84_XI0\/XLOGIC\<1\>\/MNM5_s \
 N_GND_XI4\/XI18\/MNM6_b ) N_12_LLRVT l=6e-08 w=2e-07 ad=2e-14 as=2e-14 \
 pd=4e-07 ps=4e-07 nrd=0 nrs=0 sa=4.2e-07 sb=9.4e-07 sca=9.47831 \
 scb=0.00955185 scc=0.000184287
mXI0\/XLOGIC\<1\>\/MNM0 ( N_X\<1\>_XI0\/XLOGIC\<1\>\/MNM0_d \
 N_B\<1\>_XI0\/XLOGIC\<1\>\/MNM0_g N_noxref_84_XI0\/XLOGIC\<1\>\/MNM0_s \
 N_GND_XI4\/XI18\/MNM6_b ) N_12_LLRVT l=6e-08 w=2e-07 ad=2e-14 as=3.2e-14 \
 pd=4e-07 ps=7.2e-07 nrd=0 nrs=0 sa=1.6e-07 sb=1.2e-06 sca=9.47831 \
 scb=0.00955185 scc=0.000184287
mXI0\/XLOGIC\<1\>\/MNM7 ( N_noxref_139_XI0\/XLOGIC\<1\>\/MNM7_d \
 N_CTR\<0\>_XI0\/XLOGIC\<1\>\/MNM7_g N_GND_XI0\/XLOGIC\<1\>\/MNM7_s \
 N_GND_XI4\/XI18\/MNM6_b ) N_12_LLRVT l=6e-08 w=2e-07 ad=2e-14 as=2e-14 \
 pd=4e-07 ps=4e-07 nrd=0 nrs=0 sa=9.4e-07 sb=4.2e-07 sca=9.47831 \
 scb=0.00955185 scc=0.000184287
mXI0\/XLOGIC\<1\>\/MNM6 ( N_noxref_84_XI0\/XLOGIC\<1\>\/MNM6_d \
 N_B\<1\>_XI0\/XLOGIC\<1\>\/MNM6_g N_noxref_139_XI0\/XLOGIC\<1\>\/MNM6_s \
 N_GND_XI4\/XI18\/MNM6_b ) N_12_LLRVT l=6e-08 w=2e-07 ad=3.2e-14 as=2e-14 \
 pd=7.2e-07 ps=4e-07 nrd=0 nrs=0 sa=1.2e-06 sb=1.6e-07 sca=9.47831 \
 scb=0.00955185 scc=0.000184287
mXI0\/XLOGIC\<2\>\/MNM2 ( N_noxref_90_XI0\/XLOGIC\<2\>\/MNM2_d \
 N_A\<2\>_XI0\/XLOGIC\<2\>\/MNM2_g N_GND_XI0\/XLOGIC\<2\>\/MNM2_s \
 N_GND_XI4\/XI18\/MNM6_b ) N_12_LLRVT l=6e-08 w=2e-07 ad=2e-14 as=2e-14 \
 pd=4e-07 ps=4e-07 nrd=0 nrs=0 sa=6.8e-07 sb=6.8e-07 sca=9.47831 \
 scb=0.00955185 scc=0.000184287
mXI0\/XLOGIC\<2\>\/MNM5 ( N_X\<2\>_XI0\/XLOGIC\<2\>\/MNM5_d \
 N_CTR\<1\>_XI0\/XLOGIC\<2\>\/MNM5_g N_noxref_90_XI0\/XLOGIC\<2\>\/MNM5_s \
 N_GND_XI4\/XI18\/MNM6_b ) N_12_LLRVT l=6e-08 w=2e-07 ad=2e-14 as=2e-14 \
 pd=4e-07 ps=4e-07 nrd=0 nrs=0 sa=4.2e-07 sb=9.4e-07 sca=9.47831 \
 scb=0.00955185 scc=0.000184287
mXI0\/XLOGIC\<2\>\/MNM0 ( N_X\<2\>_XI0\/XLOGIC\<2\>\/MNM0_d \
 N_B\<2\>_XI0\/XLOGIC\<2\>\/MNM0_g N_noxref_90_XI0\/XLOGIC\<2\>\/MNM0_s \
 N_GND_XI4\/XI18\/MNM6_b ) N_12_LLRVT l=6e-08 w=2e-07 ad=2e-14 as=3.2e-14 \
 pd=4e-07 ps=7.2e-07 nrd=0 nrs=0 sa=1.6e-07 sb=1.2e-06 sca=9.47831 \
 scb=0.00955185 scc=0.000184287
mXI0\/XLOGIC\<2\>\/MNM7 ( N_noxref_152_XI0\/XLOGIC\<2\>\/MNM7_d \
 N_CTR\<0\>_XI0\/XLOGIC\<2\>\/MNM7_g N_GND_XI0\/XLOGIC\<2\>\/MNM7_s \
 N_GND_XI4\/XI18\/MNM6_b ) N_12_LLRVT l=6e-08 w=2e-07 ad=2e-14 as=2e-14 \
 pd=4e-07 ps=4e-07 nrd=0 nrs=0 sa=9.4e-07 sb=4.2e-07 sca=9.47831 \
 scb=0.00955185 scc=0.000184287
mXI0\/XLOGIC\<2\>\/MNM6 ( N_noxref_90_XI0\/XLOGIC\<2\>\/MNM6_d \
 N_B\<2\>_XI0\/XLOGIC\<2\>\/MNM6_g N_noxref_152_XI0\/XLOGIC\<2\>\/MNM6_s \
 N_GND_XI4\/XI18\/MNM6_b ) N_12_LLRVT l=6e-08 w=2e-07 ad=3.2e-14 as=2e-14 \
 pd=7.2e-07 ps=4e-07 nrd=0 nrs=0 sa=1.2e-06 sb=1.6e-07 sca=9.47831 \
 scb=0.00955185 scc=0.000184287
mXI0\/XLOGIC\<3\>\/MNM2 ( N_noxref_96_XI0\/XLOGIC\<3\>\/MNM2_d \
 N_A\<3\>_XI0\/XLOGIC\<3\>\/MNM2_g N_GND_XI0\/XLOGIC\<3\>\/MNM2_s \
 N_GND_XI4\/XI18\/MNM6_b ) N_12_LLRVT l=6e-08 w=2e-07 ad=2e-14 as=2e-14 \
 pd=4e-07 ps=4e-07 nrd=0 nrs=0 sa=6.8e-07 sb=6.8e-07 sca=9.47831 \
 scb=0.00955185 scc=0.000184287
mXI0\/XLOGIC\<3\>\/MNM5 ( N_X\<3\>_XI0\/XLOGIC\<3\>\/MNM5_d \
 N_CTR\<1\>_XI0\/XLOGIC\<3\>\/MNM5_g N_noxref_96_XI0\/XLOGIC\<3\>\/MNM5_s \
 N_GND_XI4\/XI18\/MNM6_b ) N_12_LLRVT l=6e-08 w=2e-07 ad=2e-14 as=2e-14 \
 pd=4e-07 ps=4e-07 nrd=0 nrs=0 sa=4.2e-07 sb=9.4e-07 sca=9.47831 \
 scb=0.00955185 scc=0.000184287
mXI0\/XLOGIC\<3\>\/MNM0 ( N_X\<3\>_XI0\/XLOGIC\<3\>\/MNM0_d \
 N_B\<3\>_XI0\/XLOGIC\<3\>\/MNM0_g N_noxref_96_XI0\/XLOGIC\<3\>\/MNM0_s \
 N_GND_XI4\/XI18\/MNM6_b ) N_12_LLRVT l=6e-08 w=2e-07 ad=2e-14 as=3.2e-14 \
 pd=4e-07 ps=7.2e-07 nrd=0 nrs=0 sa=1.6e-07 sb=1.2e-06 sca=9.47831 \
 scb=0.00955185 scc=0.000184287
mXI0\/XLOGIC\<3\>\/MNM7 ( N_noxref_165_XI0\/XLOGIC\<3\>\/MNM7_d \
 N_CTR\<0\>_XI0\/XLOGIC\<3\>\/MNM7_g N_GND_XI0\/XLOGIC\<3\>\/MNM7_s \
 N_GND_XI4\/XI18\/MNM6_b ) N_12_LLRVT l=6e-08 w=2e-07 ad=2e-14 as=2e-14 \
 pd=4e-07 ps=4e-07 nrd=0 nrs=0 sa=9.4e-07 sb=4.2e-07 sca=9.47831 \
 scb=0.00955185 scc=0.000184287
mXI0\/XLOGIC\<3\>\/MNM6 ( N_noxref_96_XI0\/XLOGIC\<3\>\/MNM6_d \
 N_B\<3\>_XI0\/XLOGIC\<3\>\/MNM6_g N_noxref_165_XI0\/XLOGIC\<3\>\/MNM6_s \
 N_GND_XI4\/XI18\/MNM6_b ) N_12_LLRVT l=6e-08 w=2e-07 ad=3.2e-14 as=2e-14 \
 pd=7.2e-07 ps=4e-07 nrd=0 nrs=0 sa=1.2e-06 sb=1.6e-07 sca=9.47831 \
 scb=0.00955185 scc=0.000184287
mXI0\/XLOGIC\<4\>\/MNM2 ( N_noxref_102_XI0\/XLOGIC\<4\>\/MNM2_d \
 N_A\<4\>_XI0\/XLOGIC\<4\>\/MNM2_g N_GND_XI0\/XLOGIC\<4\>\/MNM2_s \
 N_GND_XI4\/XI18\/MNM6_b ) N_12_LLRVT l=6e-08 w=2e-07 ad=2e-14 as=2e-14 \
 pd=4e-07 ps=4e-07 nrd=0 nrs=0 sa=6.8e-07 sb=6.8e-07 sca=9.47831 \
 scb=0.00955185 scc=0.000184287
mXI0\/XLOGIC\<4\>\/MNM5 ( N_X\<4\>_XI0\/XLOGIC\<4\>\/MNM5_d \
 N_CTR\<1\>_XI0\/XLOGIC\<4\>\/MNM5_g N_noxref_102_XI0\/XLOGIC\<4\>\/MNM5_s \
 N_GND_XI4\/XI18\/MNM6_b ) N_12_LLRVT l=6e-08 w=2e-07 ad=2e-14 as=2e-14 \
 pd=4e-07 ps=4e-07 nrd=0 nrs=0 sa=4.2e-07 sb=9.4e-07 sca=9.47831 \
 scb=0.00955185 scc=0.000184287
mXI0\/XLOGIC\<4\>\/MNM0 ( N_X\<4\>_XI0\/XLOGIC\<4\>\/MNM0_d \
 N_B\<4\>_XI0\/XLOGIC\<4\>\/MNM0_g N_noxref_102_XI0\/XLOGIC\<4\>\/MNM0_s \
 N_GND_XI4\/XI18\/MNM6_b ) N_12_LLRVT l=6e-08 w=2e-07 ad=2e-14 as=3.2e-14 \
 pd=4e-07 ps=7.2e-07 nrd=0 nrs=0 sa=1.6e-07 sb=1.2e-06 sca=9.47831 \
 scb=0.00955185 scc=0.000184287
mXI0\/XLOGIC\<4\>\/MNM7 ( N_noxref_178_XI0\/XLOGIC\<4\>\/MNM7_d \
 N_CTR\<0\>_XI0\/XLOGIC\<4\>\/MNM7_g N_GND_XI0\/XLOGIC\<4\>\/MNM7_s \
 N_GND_XI4\/XI18\/MNM6_b ) N_12_LLRVT l=6e-08 w=2e-07 ad=2e-14 as=2e-14 \
 pd=4e-07 ps=4e-07 nrd=0 nrs=0 sa=9.4e-07 sb=4.2e-07 sca=9.47831 \
 scb=0.00955185 scc=0.000184287
mXI0\/XLOGIC\<4\>\/MNM6 ( N_noxref_102_XI0\/XLOGIC\<4\>\/MNM6_d \
 N_B\<4\>_XI0\/XLOGIC\<4\>\/MNM6_g N_noxref_178_XI0\/XLOGIC\<4\>\/MNM6_s \
 N_GND_XI4\/XI18\/MNM6_b ) N_12_LLRVT l=6e-08 w=2e-07 ad=3.2e-14 as=2e-14 \
 pd=7.2e-07 ps=4e-07 nrd=0 nrs=0 sa=1.2e-06 sb=1.6e-07 sca=9.47831 \
 scb=0.00955185 scc=0.000184287
mXI0\/XLOGIC\<5\>\/MNM2 ( N_noxref_108_XI0\/XLOGIC\<5\>\/MNM2_d \
 N_A\<5\>_XI0\/XLOGIC\<5\>\/MNM2_g N_GND_XI0\/XLOGIC\<5\>\/MNM2_s \
 N_GND_XI4\/XI18\/MNM6_b ) N_12_LLRVT l=6e-08 w=2e-07 ad=2e-14 as=2e-14 \
 pd=4e-07 ps=4e-07 nrd=0 nrs=0 sa=6.8e-07 sb=6.8e-07 sca=9.47831 \
 scb=0.00955185 scc=0.000184287
mXI0\/XLOGIC\<5\>\/MNM5 ( N_X\<5\>_XI0\/XLOGIC\<5\>\/MNM5_d \
 N_CTR\<1\>_XI0\/XLOGIC\<5\>\/MNM5_g N_noxref_108_XI0\/XLOGIC\<5\>\/MNM5_s \
 N_GND_XI4\/XI18\/MNM6_b ) N_12_LLRVT l=6e-08 w=2e-07 ad=2e-14 as=2e-14 \
 pd=4e-07 ps=4e-07 nrd=0 nrs=0 sa=4.2e-07 sb=9.4e-07 sca=9.47831 \
 scb=0.00955185 scc=0.000184287
mXI0\/XLOGIC\<5\>\/MNM0 ( N_X\<5\>_XI0\/XLOGIC\<5\>\/MNM0_d \
 N_B\<5\>_XI0\/XLOGIC\<5\>\/MNM0_g N_noxref_108_XI0\/XLOGIC\<5\>\/MNM0_s \
 N_GND_XI4\/XI18\/MNM6_b ) N_12_LLRVT l=6e-08 w=2e-07 ad=2e-14 as=3.2e-14 \
 pd=4e-07 ps=7.2e-07 nrd=0 nrs=0 sa=1.6e-07 sb=1.2e-06 sca=9.47831 \
 scb=0.00955185 scc=0.000184287
mXI0\/XLOGIC\<5\>\/MNM7 ( N_noxref_191_XI0\/XLOGIC\<5\>\/MNM7_d \
 N_CTR\<0\>_XI0\/XLOGIC\<5\>\/MNM7_g N_GND_XI0\/XLOGIC\<5\>\/MNM7_s \
 N_GND_XI4\/XI18\/MNM6_b ) N_12_LLRVT l=6e-08 w=2e-07 ad=2e-14 as=2e-14 \
 pd=4e-07 ps=4e-07 nrd=0 nrs=0 sa=9.4e-07 sb=4.2e-07 sca=9.47831 \
 scb=0.00955185 scc=0.000184287
mXI0\/XLOGIC\<5\>\/MNM6 ( N_noxref_108_XI0\/XLOGIC\<5\>\/MNM6_d \
 N_B\<5\>_XI0\/XLOGIC\<5\>\/MNM6_g N_noxref_191_XI0\/XLOGIC\<5\>\/MNM6_s \
 N_GND_XI4\/XI18\/MNM6_b ) N_12_LLRVT l=6e-08 w=2e-07 ad=3.2e-14 as=2e-14 \
 pd=7.2e-07 ps=4e-07 nrd=0 nrs=0 sa=1.2e-06 sb=1.6e-07 sca=9.47831 \
 scb=0.00955185 scc=0.000184287
mXI0\/XLOGIC\<6\>\/MNM2 ( N_noxref_114_XI0\/XLOGIC\<6\>\/MNM2_d \
 N_A\<6\>_XI0\/XLOGIC\<6\>\/MNM2_g N_GND_XI0\/XLOGIC\<6\>\/MNM2_s \
 N_GND_XI4\/XI18\/MNM6_b ) N_12_LLRVT l=6e-08 w=2e-07 ad=2e-14 as=2e-14 \
 pd=4e-07 ps=4e-07 nrd=0 nrs=0 sa=6.8e-07 sb=6.8e-07 sca=9.47831 \
 scb=0.00955185 scc=0.000184287
mXI0\/XLOGIC\<6\>\/MNM5 ( N_X\<6\>_XI0\/XLOGIC\<6\>\/MNM5_d \
 N_CTR\<1\>_XI0\/XLOGIC\<6\>\/MNM5_g N_noxref_114_XI0\/XLOGIC\<6\>\/MNM5_s \
 N_GND_XI4\/XI18\/MNM6_b ) N_12_LLRVT l=6e-08 w=2e-07 ad=2e-14 as=2e-14 \
 pd=4e-07 ps=4e-07 nrd=0 nrs=0 sa=4.2e-07 sb=9.4e-07 sca=9.47831 \
 scb=0.00955185 scc=0.000184287
mXI0\/XLOGIC\<6\>\/MNM0 ( N_X\<6\>_XI0\/XLOGIC\<6\>\/MNM0_d \
 N_B\<6\>_XI0\/XLOGIC\<6\>\/MNM0_g N_noxref_114_XI0\/XLOGIC\<6\>\/MNM0_s \
 N_GND_XI4\/XI18\/MNM6_b ) N_12_LLRVT l=6e-08 w=2e-07 ad=2e-14 as=3.2e-14 \
 pd=4e-07 ps=7.2e-07 nrd=0 nrs=0 sa=1.6e-07 sb=1.2e-06 sca=9.47831 \
 scb=0.00955185 scc=0.000184287
mXI0\/XLOGIC\<6\>\/MNM7 ( N_noxref_204_XI0\/XLOGIC\<6\>\/MNM7_d \
 N_CTR\<0\>_XI0\/XLOGIC\<6\>\/MNM7_g N_GND_XI0\/XLOGIC\<6\>\/MNM7_s \
 N_GND_XI4\/XI18\/MNM6_b ) N_12_LLRVT l=6e-08 w=2e-07 ad=2e-14 as=2e-14 \
 pd=4e-07 ps=4e-07 nrd=0 nrs=0 sa=9.4e-07 sb=4.2e-07 sca=9.47831 \
 scb=0.00955185 scc=0.000184287
mXI0\/XLOGIC\<6\>\/MNM6 ( N_noxref_114_XI0\/XLOGIC\<6\>\/MNM6_d \
 N_B\<6\>_XI0\/XLOGIC\<6\>\/MNM6_g N_noxref_204_XI0\/XLOGIC\<6\>\/MNM6_s \
 N_GND_XI4\/XI18\/MNM6_b ) N_12_LLRVT l=6e-08 w=2e-07 ad=3.2e-14 as=2e-14 \
 pd=7.2e-07 ps=4e-07 nrd=0 nrs=0 sa=1.2e-06 sb=1.6e-07 sca=9.47831 \
 scb=0.00955185 scc=0.000184287
mXI0\/XLOGIC\<7\>\/MNM2 ( N_noxref_120_XI0\/XLOGIC\<7\>\/MNM2_d \
 N_A\<7\>_XI0\/XLOGIC\<7\>\/MNM2_g N_GND_XI0\/XLOGIC\<7\>\/MNM2_s \
 N_GND_XI4\/XI18\/MNM6_b ) N_12_LLRVT l=6e-08 w=2e-07 ad=2e-14 as=2e-14 \
 pd=4e-07 ps=4e-07 nrd=0 nrs=0 sa=6.8e-07 sb=6.8e-07 sca=9.47831 \
 scb=0.00955185 scc=0.000184287
mXI0\/XLOGIC\<7\>\/MNM5 ( N_X\<7\>_XI0\/XLOGIC\<7\>\/MNM5_d \
 N_CTR\<1\>_XI0\/XLOGIC\<7\>\/MNM5_g N_noxref_120_XI0\/XLOGIC\<7\>\/MNM5_s \
 N_GND_XI4\/XI18\/MNM6_b ) N_12_LLRVT l=6e-08 w=2e-07 ad=2e-14 as=2e-14 \
 pd=4e-07 ps=4e-07 nrd=0 nrs=0 sa=4.2e-07 sb=9.4e-07 sca=9.47831 \
 scb=0.00955185 scc=0.000184287
mXI0\/XLOGIC\<7\>\/MNM0 ( N_X\<7\>_XI0\/XLOGIC\<7\>\/MNM0_d \
 N_B\<7\>_XI0\/XLOGIC\<7\>\/MNM0_g N_noxref_120_XI0\/XLOGIC\<7\>\/MNM0_s \
 N_GND_XI4\/XI18\/MNM6_b ) N_12_LLRVT l=6e-08 w=2e-07 ad=2e-14 as=3.2e-14 \
 pd=4e-07 ps=7.2e-07 nrd=0 nrs=0 sa=1.6e-07 sb=1.2e-06 sca=9.47831 \
 scb=0.00955185 scc=0.000184287
mXI0\/XLOGIC\<7\>\/MNM7 ( N_noxref_217_XI0\/XLOGIC\<7\>\/MNM7_d \
 N_CTR\<0\>_XI0\/XLOGIC\<7\>\/MNM7_g N_GND_XI0\/XLOGIC\<7\>\/MNM7_s \
 N_GND_XI4\/XI18\/MNM6_b ) N_12_LLRVT l=6e-08 w=2e-07 ad=2e-14 as=2e-14 \
 pd=4e-07 ps=4e-07 nrd=0 nrs=0 sa=9.4e-07 sb=4.2e-07 sca=9.47831 \
 scb=0.00955185 scc=0.000184287
mXI0\/XLOGIC\<7\>\/MNM6 ( N_noxref_120_XI0\/XLOGIC\<7\>\/MNM6_d \
 N_B\<7\>_XI0\/XLOGIC\<7\>\/MNM6_g N_noxref_217_XI0\/XLOGIC\<7\>\/MNM6_s \
 N_GND_XI4\/XI18\/MNM6_b ) N_12_LLRVT l=6e-08 w=2e-07 ad=3.2e-14 as=2e-14 \
 pd=7.2e-07 ps=4e-07 nrd=0 nrs=0 sa=1.2e-06 sb=1.6e-07 sca=9.47831 \
 scb=0.00955185 scc=0.000184287
//
include "/home/edauser64/edalab2022_fullcust/CDS_VISO/EDATP/ALU_8bit_PEX/spectreText/spectre.scs.ALU_8BIT.pxi"
//
ends ALU_8BIT_PEX
//
//
