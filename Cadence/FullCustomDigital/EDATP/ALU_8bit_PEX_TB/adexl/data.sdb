ADE simulation setup
Run mode: Single Run, Sweeps and Corners
Tests:
  EDATP:ALU_8bit_PEX_TB:1: EDATP/ALU_8bit_PEX_TB/schematic, simulator spectre
    Outputs: /B_PEX<0>; /O_PEX<7>; /B<0>; /O<7>
Global variables:
  period = 2n
  vdd = 1.2
