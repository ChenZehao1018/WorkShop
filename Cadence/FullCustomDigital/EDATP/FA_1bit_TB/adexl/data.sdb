ADE simulation setup
Run mode: Single Run, Sweeps and Corners
Tests:
  EDATP:FA_1bit_TB:1: EDATP/FA_1bit_TB/schematic, simulator spectre
    Outputs: /net3; /A; /B; /Ci; /C0; /S
Global variables:
  Tp = 2n
  VDD = 1.2
