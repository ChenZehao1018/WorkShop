ADE simulation setup
Run mode: Single Run, Sweeps and Corners
Tests:
  EDATP:FlipFlop_Ratioed_TB:1: EDATP/FlipFlop_Ratioed_TB/schematic, simulator spectre
    Outputs: /CLK; /I; /O
