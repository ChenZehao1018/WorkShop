ADE simulation setup
Run mode: Single Run, Sweeps and Corners
Tests:
  EDATP:FlipFlop_TB:1: EDATP/FlipFlop_TB/schematic, simulator spectre
    Outputs: /I; /O; /CLK
