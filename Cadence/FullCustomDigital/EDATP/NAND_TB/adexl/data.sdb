ADE simulation setup
Run mode: Single Run, Sweeps and Corners
Tests:
  EDATP:NAND_TB:1: EDATP/NAND_TB/schematic, simulator spectre
    Outputs: "/"; /; /net5; /net3; /net4
Global variables:
  VDD = 1.2
  period = 2n
  Tsim = 32*period
