ADE simulation setup
Run mode: Single Run, Sweeps and Corners
Tests:
  project_4x:RowDecoder_256_4xP_TB:1: project_4x/RowDecoder_256_4xP_TB/schematic, simulator spectre
    Outputs: /A<7:0>; WL; delay(?wf1 VT("/A<1>") ?value1 0.5 ?edge1 "rising" ?nth1 1 ?td1 0.0 ?tol1 nil ?wf2 VT("/WL<0>") ?value2 0.5 ?edge2 "rising" ?nth2 1 ?tol2 nil ?td2 nil ?stop nil ?multiple nil); delay timeWL1; /I18/IPost<1>/WL; Postin; Prein; Preout
