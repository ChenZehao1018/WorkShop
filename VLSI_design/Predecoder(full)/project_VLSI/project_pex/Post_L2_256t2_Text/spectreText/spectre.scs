// File: /home/edauser0/ayigit/RowDecoder_Project/CDS_VISIO/project_pex/Post_L2_256t2_Text/spectreText/spectre.scs
// Created: Tue Dec 21 12:19:14 2021
// Program "Calibre xRC"
// Version "v2020.1_17.9"
//
simulator lang=spectre
include "/home/edauser60/2022_project/CDS_VISIO/project_pex/Post_L2_256t2_Text/spectreText/spectre.scs.pex"
subckt Post_L2_256t2_Text (  SEL1\<15\> WLSEL\<511\> SEL0\<15\> WLSEL\<510\> \
 WLSEL\<509\> SEL0\<14\> WLSEL\<508\> WLSEL\<507\> SEL0\<13\> WLSEL\<506\> \
 WLSEL\<505\> SEL0\<12\> WLSEL\<504\> WLSEL\<503\> SEL0\<11\> WLSEL\<502\> \
 WLSEL\<501\> SEL0\<10\> WLSEL\<500\> WLSEL\<499\> SEL0\<9\> WLSEL\<498\> \
 WLSEL\<497\> SEL0\<8\> WLSEL\<496\> WLSEL\<495\> SEL0\<7\> WLSEL\<494\> \
 WLSEL\<493\> SEL0\<6\> WLSEL\<492\> WLSEL\<491\> SEL0\<5\> WLSEL\<490\> \
 WLSEL\<489\> SEL0\<4\> WLSEL\<488\> WLSEL\<487\> SEL0\<3\> WLSEL\<486\> \
 WLSEL\<485\> SEL0\<2\> WLSEL\<484\> WLSEL\<483\> SEL0\<1\> WLSEL\<482\> \
 WLSEL\<481\> SEL0\<0\> WLSEL\<480\> SEL1\<14\> WLSEL\<479\> WLSEL\<478\> \
 WLSEL\<477\> WLSEL\<476\> WLSEL\<475\> WLSEL\<474\> WLSEL\<473\> WLSEL\<472\> \
 WLSEL\<471\> WLSEL\<470\> WLSEL\<469\> WLSEL\<468\> WLSEL\<467\> WLSEL\<466\> \
 WLSEL\<465\> WLSEL\<464\> WLSEL\<463\> WLSEL\<462\> WLSEL\<461\> WLSEL\<460\> \
 WLSEL\<459\> WLSEL\<458\> WLSEL\<457\> WLSEL\<456\> WLSEL\<455\> WLSEL\<454\> \
 WLSEL\<453\> WLSEL\<452\> WLSEL\<451\> WLSEL\<450\> WLSEL\<449\> WLSEL\<448\> \
 SEL1\<13\> WLSEL\<447\> WLSEL\<446\> WLSEL\<445\> WLSEL\<444\> WLSEL\<443\> \
 WLSEL\<442\> WLSEL\<441\> WLSEL\<440\> WLSEL\<439\> WLSEL\<438\> WLSEL\<437\> \
 WLSEL\<436\> WLSEL\<435\> WLSEL\<434\> WLSEL\<433\> WLSEL\<432\> WLSEL\<431\> \
 WLSEL\<430\> WLSEL\<429\> WLSEL\<428\> WLSEL\<427\> WLSEL\<426\> WLSEL\<425\> \
 WLSEL\<424\> WLSEL\<423\> WLSEL\<422\> WLSEL\<421\> WLSEL\<420\> WLSEL\<419\> \
 WLSEL\<418\> WLSEL\<417\> WLSEL\<416\> SEL1\<12\> WLSEL\<415\> WLSEL\<414\> \
 WLSEL\<413\> WLSEL\<412\> WLSEL\<411\> WLSEL\<410\> WLSEL\<409\> WLSEL\<408\> \
 WLSEL\<407\> WLSEL\<406\> WLSEL\<405\> WLSEL\<404\> WLSEL\<403\> WLSEL\<402\> \
 WLSEL\<401\> WLSEL\<400\> WLSEL\<399\> WLSEL\<398\> WLSEL\<397\> WLSEL\<396\> \
 WLSEL\<395\> WLSEL\<394\> WLSEL\<393\> WLSEL\<392\> WLSEL\<391\> WLSEL\<390\> \
 WLSEL\<389\> WLSEL\<388\> WLSEL\<387\> WLSEL\<386\> WLSEL\<385\> WLSEL\<384\> \
 SEL1\<11\> WLSEL\<383\> WLSEL\<382\> WLSEL\<381\> WLSEL\<380\> WLSEL\<379\> \
 WLSEL\<378\> WLSEL\<377\> WLSEL\<376\> WLSEL\<375\> WLSEL\<374\> WLSEL\<373\> \
 WLSEL\<372\> WLSEL\<371\> WLSEL\<370\> WLSEL\<369\> WLSEL\<368\> WLSEL\<367\> \
 WLSEL\<366\> WLSEL\<365\> WLSEL\<364\> WLSEL\<363\> WLSEL\<362\> WLSEL\<361\> \
 WLSEL\<360\> WLSEL\<359\> WLSEL\<358\> WLSEL\<357\> WLSEL\<356\> WLSEL\<355\> \
 WLSEL\<354\> WLSEL\<353\> WLSEL\<352\> SEL1\<10\> WLSEL\<351\> WLSEL\<350\> \
 WLSEL\<349\> WLSEL\<348\> WLSEL\<347\> WLSEL\<346\> WLSEL\<345\> WLSEL\<344\> \
 WLSEL\<343\> WLSEL\<342\> WLSEL\<341\> WLSEL\<340\> WLSEL\<339\> WLSEL\<338\> \
 WLSEL\<337\> WLSEL\<336\> WLSEL\<335\> WLSEL\<334\> WLSEL\<333\> WLSEL\<332\> \
 WLSEL\<331\> WLSEL\<330\> WLSEL\<329\> WLSEL\<328\> WLSEL\<327\> WLSEL\<326\> \
 WLSEL\<325\> WLSEL\<324\> WLSEL\<323\> WLSEL\<322\> WLSEL\<321\> WLSEL\<320\> \
 SEL1\<9\> WLSEL\<319\> WLSEL\<318\> WLSEL\<317\> WLSEL\<316\> WLSEL\<315\> \
 WLSEL\<314\> WLSEL\<313\> WLSEL\<312\> WLSEL\<311\> WLSEL\<310\> WLSEL\<309\> \
 WLSEL\<308\> WLSEL\<307\> WLSEL\<306\> WLSEL\<305\> WLSEL\<304\> WLSEL\<303\> \
 WLSEL\<302\> WLSEL\<301\> WLSEL\<300\> WLSEL\<299\> WLSEL\<298\> WLSEL\<297\> \
 WLSEL\<296\> WLSEL\<295\> WLSEL\<294\> WLSEL\<293\> WLSEL\<292\> WLSEL\<291\> \
 WLSEL\<290\> WLSEL\<289\> WLSEL\<288\> SEL1\<8\> WLSEL\<287\> WLSEL\<286\> \
 WLSEL\<285\> WLSEL\<284\> WLSEL\<283\> WLSEL\<282\> WLSEL\<281\> WLSEL\<280\> \
 WLSEL\<279\> WLSEL\<278\> WLSEL\<277\> WLSEL\<276\> WLSEL\<275\> WLSEL\<274\> \
 WLSEL\<273\> WLSEL\<272\> WLSEL\<271\> WLSEL\<270\> WLSEL\<269\> WLSEL\<268\> \
 WLSEL\<267\> WLSEL\<266\> WLSEL\<265\> WLSEL\<264\> WLSEL\<263\> WLSEL\<262\> \
 WLSEL\<261\> WLSEL\<260\> WLSEL\<259\> WLSEL\<258\> WLSEL\<257\> WLSEL\<256\> \
 SEL1\<7\> WLSEL\<255\> WLSEL\<254\> WLSEL\<253\> WLSEL\<252\> WLSEL\<251\> \
 WLSEL\<250\> WLSEL\<249\> WLSEL\<248\> WLSEL\<247\> WLSEL\<246\> WLSEL\<245\> \
 WLSEL\<244\> WLSEL\<243\> WLSEL\<242\> WLSEL\<241\> WLSEL\<240\> WLSEL\<239\> \
 WLSEL\<238\> WLSEL\<237\> WLSEL\<236\> WLSEL\<235\> WLSEL\<234\> WLSEL\<233\> \
 WLSEL\<232\> WLSEL\<231\> WLSEL\<230\> WLSEL\<229\> WLSEL\<228\> WLSEL\<227\> \
 WLSEL\<226\> WLSEL\<225\> WLSEL\<224\> SEL1\<6\> WLSEL\<223\> WLSEL\<222\> \
 WLSEL\<221\> WLSEL\<220\> WLSEL\<219\> WLSEL\<218\> WLSEL\<217\> WLSEL\<216\> \
 WLSEL\<215\> WLSEL\<214\> WLSEL\<213\> WLSEL\<212\> WLSEL\<211\> WLSEL\<210\> \
 WLSEL\<209\> WLSEL\<208\> WLSEL\<207\> WLSEL\<206\> WLSEL\<205\> WLSEL\<204\> \
 WLSEL\<203\> WLSEL\<202\> WLSEL\<201\> WLSEL\<200\> WLSEL\<199\> WLSEL\<198\> \
 WLSEL\<197\> WLSEL\<196\> WLSEL\<195\> WLSEL\<194\> WLSEL\<193\> WLSEL\<192\> \
 SEL1\<5\> WLSEL\<191\> WLSEL\<190\> WLSEL\<189\> WLSEL\<188\> WLSEL\<187\> \
 WLSEL\<186\> WLSEL\<185\> WLSEL\<184\> WLSEL\<183\> WLSEL\<182\> WLSEL\<181\> \
 WLSEL\<180\> WLSEL\<179\> WLSEL\<178\> WLSEL\<177\> WLSEL\<176\> WLSEL\<175\> \
 WLSEL\<174\> WLSEL\<173\> WLSEL\<172\> WLSEL\<171\> WLSEL\<170\> WLSEL\<169\> \
 WLSEL\<168\> WLSEL\<167\> WLSEL\<166\> WLSEL\<165\> WLSEL\<164\> WLSEL\<163\> \
 WLSEL\<162\> WLSEL\<161\> WLSEL\<160\> SEL1\<4\> WLSEL\<159\> WLSEL\<158\> \
 WLSEL\<157\> WLSEL\<156\> WLSEL\<155\> WLSEL\<154\> WLSEL\<153\> WLSEL\<152\> \
 WLSEL\<151\> WLSEL\<150\> WLSEL\<149\> WLSEL\<148\> WLSEL\<147\> WLSEL\<146\> \
 WLSEL\<145\> WLSEL\<144\> WLSEL\<143\> WLSEL\<142\> WLSEL\<141\> WLSEL\<140\> \
 WLSEL\<139\> WLSEL\<138\> WLSEL\<137\> WLSEL\<136\> WLSEL\<135\> WLSEL\<134\> \
 WLSEL\<133\> WLSEL\<132\> WLSEL\<131\> WLSEL\<130\> WLSEL\<129\> WLSEL\<128\> \
 SEL1\<3\> WLSEL\<127\> WLSEL\<126\> WLSEL\<125\> WLSEL\<124\> WLSEL\<123\> \
 WLSEL\<122\> WLSEL\<121\> WLSEL\<120\> WLSEL\<119\> WLSEL\<118\> WLSEL\<117\> \
 WLSEL\<116\> WLSEL\<115\> WLSEL\<114\> WLSEL\<113\> WLSEL\<112\> WLSEL\<111\> \
 WLSEL\<110\> WLSEL\<109\> WLSEL\<108\> WLSEL\<107\> WLSEL\<106\> WLSEL\<105\> \
 WLSEL\<104\> WLSEL\<103\> WLSEL\<102\> WLSEL\<101\> WLSEL\<100\> WLSEL\<99\> \
 WLSEL\<98\> WLSEL\<97\> WLSEL\<96\> SEL1\<2\> WLSEL\<95\> WLSEL\<94\> \
 WLSEL\<93\> WLSEL\<92\> WLSEL\<91\> WLSEL\<90\> WLSEL\<89\> WLSEL\<88\> \
 WLSEL\<87\> WLSEL\<86\> WLSEL\<85\> WLSEL\<84\> WLSEL\<83\> WLSEL\<82\> \
 WLSEL\<81\> WLSEL\<80\> WLSEL\<79\> WLSEL\<78\> WLSEL\<77\> WLSEL\<76\> \
 WLSEL\<75\> WLSEL\<74\> WLSEL\<73\> WLSEL\<72\> WLSEL\<71\> WLSEL\<70\> \
 WLSEL\<69\> WLSEL\<68\> WLSEL\<67\> WLSEL\<66\> WLSEL\<65\> WLSEL\<64\> \
 SEL1\<1\> WLSEL\<63\> WLSEL\<62\> WLSEL\<61\> WLSEL\<60\> WLSEL\<59\> \
 WLSEL\<58\> WLSEL\<57\> WLSEL\<56\> WLSEL\<55\> WLSEL\<54\> WLSEL\<53\> \
 WLSEL\<52\> WLSEL\<51\> WLSEL\<50\> WLSEL\<49\> WLSEL\<48\> WLSEL\<47\> \
 WLSEL\<46\> WLSEL\<45\> WLSEL\<44\> WLSEL\<43\> WLSEL\<42\> WLSEL\<41\> \
 WLSEL\<40\> WLSEL\<39\> WLSEL\<38\> WLSEL\<37\> WLSEL\<36\> WLSEL\<35\> \
 WLSEL\<34\> WLSEL\<33\> WLSEL\<32\> SEL1\<0\> WLSEL\<31\> WLSEL\<30\> \
 WLSEL\<29\> WLSEL\<28\> WLSEL\<27\> WLSEL\<26\> WLSEL\<25\> WLSEL\<24\> \
 WLSEL\<23\> WLSEL\<22\> WLSEL\<21\> WLSEL\<20\> WLSEL\<19\> WLSEL\<18\> \
 WLSEL\<17\> WLSEL\<16\> WLSEL\<15\> WLSEL\<14\> WLSEL\<13\> WLSEL\<12\> \
 WLSEL\<11\> WLSEL\<10\> WLSEL\<9\> WLSEL\<8\> WLSEL\<7\> WLSEL\<6\> \
 WLSEL\<5\> WLSEL\<4\> WLSEL\<3\> WLSEL\<2\> WLSEL\<1\> WLSEL\<0\> )
//
// WLSEL<0>	WLSEL<0>
// WLSEL<1>	WLSEL<1>
// WLSEL<2>	WLSEL<2>
// WLSEL<3>	WLSEL<3>
// WLSEL<4>	WLSEL<4>
// WLSEL<5>	WLSEL<5>
// WLSEL<6>	WLSEL<6>
// WLSEL<7>	WLSEL<7>
// WLSEL<8>	WLSEL<8>
// WLSEL<9>	WLSEL<9>
// WLSEL<10>	WLSEL<10>
// WLSEL<11>	WLSEL<11>
// WLSEL<12>	WLSEL<12>
// WLSEL<13>	WLSEL<13>
// WLSEL<14>	WLSEL<14>
// WLSEL<15>	WLSEL<15>
// WLSEL<16>	WLSEL<16>
// WLSEL<17>	WLSEL<17>
// WLSEL<18>	WLSEL<18>
// WLSEL<19>	WLSEL<19>
// WLSEL<20>	WLSEL<20>
// WLSEL<21>	WLSEL<21>
// WLSEL<22>	WLSEL<22>
// WLSEL<23>	WLSEL<23>
// WLSEL<24>	WLSEL<24>
// WLSEL<25>	WLSEL<25>
// WLSEL<26>	WLSEL<26>
// WLSEL<27>	WLSEL<27>
// WLSEL<28>	WLSEL<28>
// WLSEL<29>	WLSEL<29>
// WLSEL<30>	WLSEL<30>
// WLSEL<31>	WLSEL<31>
// SEL1<0>	SEL1<0>
// WLSEL<32>	WLSEL<32>
// WLSEL<33>	WLSEL<33>
// WLSEL<34>	WLSEL<34>
// WLSEL<35>	WLSEL<35>
// WLSEL<36>	WLSEL<36>
// WLSEL<37>	WLSEL<37>
// WLSEL<38>	WLSEL<38>
// WLSEL<39>	WLSEL<39>
// WLSEL<40>	WLSEL<40>
// WLSEL<41>	WLSEL<41>
// WLSEL<42>	WLSEL<42>
// WLSEL<43>	WLSEL<43>
// WLSEL<44>	WLSEL<44>
// WLSEL<45>	WLSEL<45>
// WLSEL<46>	WLSEL<46>
// WLSEL<47>	WLSEL<47>
// WLSEL<48>	WLSEL<48>
// WLSEL<49>	WLSEL<49>
// WLSEL<50>	WLSEL<50>
// WLSEL<51>	WLSEL<51>
// WLSEL<52>	WLSEL<52>
// WLSEL<53>	WLSEL<53>
// WLSEL<54>	WLSEL<54>
// WLSEL<55>	WLSEL<55>
// WLSEL<56>	WLSEL<56>
// WLSEL<57>	WLSEL<57>
// WLSEL<58>	WLSEL<58>
// WLSEL<59>	WLSEL<59>
// WLSEL<60>	WLSEL<60>
// WLSEL<61>	WLSEL<61>
// WLSEL<62>	WLSEL<62>
// WLSEL<63>	WLSEL<63>
// SEL1<1>	SEL1<1>
// WLSEL<64>	WLSEL<64>
// WLSEL<65>	WLSEL<65>
// WLSEL<66>	WLSEL<66>
// WLSEL<67>	WLSEL<67>
// WLSEL<68>	WLSEL<68>
// WLSEL<69>	WLSEL<69>
// WLSEL<70>	WLSEL<70>
// WLSEL<71>	WLSEL<71>
// WLSEL<72>	WLSEL<72>
// WLSEL<73>	WLSEL<73>
// WLSEL<74>	WLSEL<74>
// WLSEL<75>	WLSEL<75>
// WLSEL<76>	WLSEL<76>
// WLSEL<77>	WLSEL<77>
// WLSEL<78>	WLSEL<78>
// WLSEL<79>	WLSEL<79>
// WLSEL<80>	WLSEL<80>
// WLSEL<81>	WLSEL<81>
// WLSEL<82>	WLSEL<82>
// WLSEL<83>	WLSEL<83>
// WLSEL<84>	WLSEL<84>
// WLSEL<85>	WLSEL<85>
// WLSEL<86>	WLSEL<86>
// WLSEL<87>	WLSEL<87>
// WLSEL<88>	WLSEL<88>
// WLSEL<89>	WLSEL<89>
// WLSEL<90>	WLSEL<90>
// WLSEL<91>	WLSEL<91>
// WLSEL<92>	WLSEL<92>
// WLSEL<93>	WLSEL<93>
// WLSEL<94>	WLSEL<94>
// WLSEL<95>	WLSEL<95>
// SEL1<2>	SEL1<2>
// WLSEL<96>	WLSEL<96>
// WLSEL<97>	WLSEL<97>
// WLSEL<98>	WLSEL<98>
// WLSEL<99>	WLSEL<99>
// WLSEL<100>	WLSEL<100>
// WLSEL<101>	WLSEL<101>
// WLSEL<102>	WLSEL<102>
// WLSEL<103>	WLSEL<103>
// WLSEL<104>	WLSEL<104>
// WLSEL<105>	WLSEL<105>
// WLSEL<106>	WLSEL<106>
// WLSEL<107>	WLSEL<107>
// WLSEL<108>	WLSEL<108>
// WLSEL<109>	WLSEL<109>
// WLSEL<110>	WLSEL<110>
// WLSEL<111>	WLSEL<111>
// WLSEL<112>	WLSEL<112>
// WLSEL<113>	WLSEL<113>
// WLSEL<114>	WLSEL<114>
// WLSEL<115>	WLSEL<115>
// WLSEL<116>	WLSEL<116>
// WLSEL<117>	WLSEL<117>
// WLSEL<118>	WLSEL<118>
// WLSEL<119>	WLSEL<119>
// WLSEL<120>	WLSEL<120>
// WLSEL<121>	WLSEL<121>
// WLSEL<122>	WLSEL<122>
// WLSEL<123>	WLSEL<123>
// WLSEL<124>	WLSEL<124>
// WLSEL<125>	WLSEL<125>
// WLSEL<126>	WLSEL<126>
// WLSEL<127>	WLSEL<127>
// SEL1<3>	SEL1<3>
// WLSEL<128>	WLSEL<128>
// WLSEL<129>	WLSEL<129>
// WLSEL<130>	WLSEL<130>
// WLSEL<131>	WLSEL<131>
// WLSEL<132>	WLSEL<132>
// WLSEL<133>	WLSEL<133>
// WLSEL<134>	WLSEL<134>
// WLSEL<135>	WLSEL<135>
// WLSEL<136>	WLSEL<136>
// WLSEL<137>	WLSEL<137>
// WLSEL<138>	WLSEL<138>
// WLSEL<139>	WLSEL<139>
// WLSEL<140>	WLSEL<140>
// WLSEL<141>	WLSEL<141>
// WLSEL<142>	WLSEL<142>
// WLSEL<143>	WLSEL<143>
// WLSEL<144>	WLSEL<144>
// WLSEL<145>	WLSEL<145>
// WLSEL<146>	WLSEL<146>
// WLSEL<147>	WLSEL<147>
// WLSEL<148>	WLSEL<148>
// WLSEL<149>	WLSEL<149>
// WLSEL<150>	WLSEL<150>
// WLSEL<151>	WLSEL<151>
// WLSEL<152>	WLSEL<152>
// WLSEL<153>	WLSEL<153>
// WLSEL<154>	WLSEL<154>
// WLSEL<155>	WLSEL<155>
// WLSEL<156>	WLSEL<156>
// WLSEL<157>	WLSEL<157>
// WLSEL<158>	WLSEL<158>
// WLSEL<159>	WLSEL<159>
// SEL1<4>	SEL1<4>
// WLSEL<160>	WLSEL<160>
// WLSEL<161>	WLSEL<161>
// WLSEL<162>	WLSEL<162>
// WLSEL<163>	WLSEL<163>
// WLSEL<164>	WLSEL<164>
// WLSEL<165>	WLSEL<165>
// WLSEL<166>	WLSEL<166>
// WLSEL<167>	WLSEL<167>
// WLSEL<168>	WLSEL<168>
// WLSEL<169>	WLSEL<169>
// WLSEL<170>	WLSEL<170>
// WLSEL<171>	WLSEL<171>
// WLSEL<172>	WLSEL<172>
// WLSEL<173>	WLSEL<173>
// WLSEL<174>	WLSEL<174>
// WLSEL<175>	WLSEL<175>
// WLSEL<176>	WLSEL<176>
// WLSEL<177>	WLSEL<177>
// WLSEL<178>	WLSEL<178>
// WLSEL<179>	WLSEL<179>
// WLSEL<180>	WLSEL<180>
// WLSEL<181>	WLSEL<181>
// WLSEL<182>	WLSEL<182>
// WLSEL<183>	WLSEL<183>
// WLSEL<184>	WLSEL<184>
// WLSEL<185>	WLSEL<185>
// WLSEL<186>	WLSEL<186>
// WLSEL<187>	WLSEL<187>
// WLSEL<188>	WLSEL<188>
// WLSEL<189>	WLSEL<189>
// WLSEL<190>	WLSEL<190>
// WLSEL<191>	WLSEL<191>
// SEL1<5>	SEL1<5>
// WLSEL<192>	WLSEL<192>
// WLSEL<193>	WLSEL<193>
// WLSEL<194>	WLSEL<194>
// WLSEL<195>	WLSEL<195>
// WLSEL<196>	WLSEL<196>
// WLSEL<197>	WLSEL<197>
// WLSEL<198>	WLSEL<198>
// WLSEL<199>	WLSEL<199>
// WLSEL<200>	WLSEL<200>
// WLSEL<201>	WLSEL<201>
// WLSEL<202>	WLSEL<202>
// WLSEL<203>	WLSEL<203>
// WLSEL<204>	WLSEL<204>
// WLSEL<205>	WLSEL<205>
// WLSEL<206>	WLSEL<206>
// WLSEL<207>	WLSEL<207>
// WLSEL<208>	WLSEL<208>
// WLSEL<209>	WLSEL<209>
// WLSEL<210>	WLSEL<210>
// WLSEL<211>	WLSEL<211>
// WLSEL<212>	WLSEL<212>
// WLSEL<213>	WLSEL<213>
// WLSEL<214>	WLSEL<214>
// WLSEL<215>	WLSEL<215>
// WLSEL<216>	WLSEL<216>
// WLSEL<217>	WLSEL<217>
// WLSEL<218>	WLSEL<218>
// WLSEL<219>	WLSEL<219>
// WLSEL<220>	WLSEL<220>
// WLSEL<221>	WLSEL<221>
// WLSEL<222>	WLSEL<222>
// WLSEL<223>	WLSEL<223>
// SEL1<6>	SEL1<6>
// WLSEL<224>	WLSEL<224>
// WLSEL<225>	WLSEL<225>
// WLSEL<226>	WLSEL<226>
// WLSEL<227>	WLSEL<227>
// WLSEL<228>	WLSEL<228>
// WLSEL<229>	WLSEL<229>
// WLSEL<230>	WLSEL<230>
// WLSEL<231>	WLSEL<231>
// WLSEL<232>	WLSEL<232>
// WLSEL<233>	WLSEL<233>
// WLSEL<234>	WLSEL<234>
// WLSEL<235>	WLSEL<235>
// WLSEL<236>	WLSEL<236>
// WLSEL<237>	WLSEL<237>
// WLSEL<238>	WLSEL<238>
// WLSEL<239>	WLSEL<239>
// WLSEL<240>	WLSEL<240>
// WLSEL<241>	WLSEL<241>
// WLSEL<242>	WLSEL<242>
// WLSEL<243>	WLSEL<243>
// WLSEL<244>	WLSEL<244>
// WLSEL<245>	WLSEL<245>
// WLSEL<246>	WLSEL<246>
// WLSEL<247>	WLSEL<247>
// WLSEL<248>	WLSEL<248>
// WLSEL<249>	WLSEL<249>
// WLSEL<250>	WLSEL<250>
// WLSEL<251>	WLSEL<251>
// WLSEL<252>	WLSEL<252>
// WLSEL<253>	WLSEL<253>
// WLSEL<254>	WLSEL<254>
// WLSEL<255>	WLSEL<255>
// SEL1<7>	SEL1<7>
// WLSEL<256>	WLSEL<256>
// WLSEL<257>	WLSEL<257>
// WLSEL<258>	WLSEL<258>
// WLSEL<259>	WLSEL<259>
// WLSEL<260>	WLSEL<260>
// WLSEL<261>	WLSEL<261>
// WLSEL<262>	WLSEL<262>
// WLSEL<263>	WLSEL<263>
// WLSEL<264>	WLSEL<264>
// WLSEL<265>	WLSEL<265>
// WLSEL<266>	WLSEL<266>
// WLSEL<267>	WLSEL<267>
// WLSEL<268>	WLSEL<268>
// WLSEL<269>	WLSEL<269>
// WLSEL<270>	WLSEL<270>
// WLSEL<271>	WLSEL<271>
// WLSEL<272>	WLSEL<272>
// WLSEL<273>	WLSEL<273>
// WLSEL<274>	WLSEL<274>
// WLSEL<275>	WLSEL<275>
// WLSEL<276>	WLSEL<276>
// WLSEL<277>	WLSEL<277>
// WLSEL<278>	WLSEL<278>
// WLSEL<279>	WLSEL<279>
// WLSEL<280>	WLSEL<280>
// WLSEL<281>	WLSEL<281>
// WLSEL<282>	WLSEL<282>
// WLSEL<283>	WLSEL<283>
// WLSEL<284>	WLSEL<284>
// WLSEL<285>	WLSEL<285>
// WLSEL<286>	WLSEL<286>
// WLSEL<287>	WLSEL<287>
// SEL1<8>	SEL1<8>
// WLSEL<288>	WLSEL<288>
// WLSEL<289>	WLSEL<289>
// WLSEL<290>	WLSEL<290>
// WLSEL<291>	WLSEL<291>
// WLSEL<292>	WLSEL<292>
// WLSEL<293>	WLSEL<293>
// WLSEL<294>	WLSEL<294>
// WLSEL<295>	WLSEL<295>
// WLSEL<296>	WLSEL<296>
// WLSEL<297>	WLSEL<297>
// WLSEL<298>	WLSEL<298>
// WLSEL<299>	WLSEL<299>
// WLSEL<300>	WLSEL<300>
// WLSEL<301>	WLSEL<301>
// WLSEL<302>	WLSEL<302>
// WLSEL<303>	WLSEL<303>
// WLSEL<304>	WLSEL<304>
// WLSEL<305>	WLSEL<305>
// WLSEL<306>	WLSEL<306>
// WLSEL<307>	WLSEL<307>
// WLSEL<308>	WLSEL<308>
// WLSEL<309>	WLSEL<309>
// WLSEL<310>	WLSEL<310>
// WLSEL<311>	WLSEL<311>
// WLSEL<312>	WLSEL<312>
// WLSEL<313>	WLSEL<313>
// WLSEL<314>	WLSEL<314>
// WLSEL<315>	WLSEL<315>
// WLSEL<316>	WLSEL<316>
// WLSEL<317>	WLSEL<317>
// WLSEL<318>	WLSEL<318>
// WLSEL<319>	WLSEL<319>
// SEL1<9>	SEL1<9>
// WLSEL<320>	WLSEL<320>
// WLSEL<321>	WLSEL<321>
// WLSEL<322>	WLSEL<322>
// WLSEL<323>	WLSEL<323>
// WLSEL<324>	WLSEL<324>
// WLSEL<325>	WLSEL<325>
// WLSEL<326>	WLSEL<326>
// WLSEL<327>	WLSEL<327>
// WLSEL<328>	WLSEL<328>
// WLSEL<329>	WLSEL<329>
// WLSEL<330>	WLSEL<330>
// WLSEL<331>	WLSEL<331>
// WLSEL<332>	WLSEL<332>
// WLSEL<333>	WLSEL<333>
// WLSEL<334>	WLSEL<334>
// WLSEL<335>	WLSEL<335>
// WLSEL<336>	WLSEL<336>
// WLSEL<337>	WLSEL<337>
// WLSEL<338>	WLSEL<338>
// WLSEL<339>	WLSEL<339>
// WLSEL<340>	WLSEL<340>
// WLSEL<341>	WLSEL<341>
// WLSEL<342>	WLSEL<342>
// WLSEL<343>	WLSEL<343>
// WLSEL<344>	WLSEL<344>
// WLSEL<345>	WLSEL<345>
// WLSEL<346>	WLSEL<346>
// WLSEL<347>	WLSEL<347>
// WLSEL<348>	WLSEL<348>
// WLSEL<349>	WLSEL<349>
// WLSEL<350>	WLSEL<350>
// WLSEL<351>	WLSEL<351>
// SEL1<10>	SEL1<10>
// WLSEL<352>	WLSEL<352>
// WLSEL<353>	WLSEL<353>
// WLSEL<354>	WLSEL<354>
// WLSEL<355>	WLSEL<355>
// WLSEL<356>	WLSEL<356>
// WLSEL<357>	WLSEL<357>
// WLSEL<358>	WLSEL<358>
// WLSEL<359>	WLSEL<359>
// WLSEL<360>	WLSEL<360>
// WLSEL<361>	WLSEL<361>
// WLSEL<362>	WLSEL<362>
// WLSEL<363>	WLSEL<363>
// WLSEL<364>	WLSEL<364>
// WLSEL<365>	WLSEL<365>
// WLSEL<366>	WLSEL<366>
// WLSEL<367>	WLSEL<367>
// WLSEL<368>	WLSEL<368>
// WLSEL<369>	WLSEL<369>
// WLSEL<370>	WLSEL<370>
// WLSEL<371>	WLSEL<371>
// WLSEL<372>	WLSEL<372>
// WLSEL<373>	WLSEL<373>
// WLSEL<374>	WLSEL<374>
// WLSEL<375>	WLSEL<375>
// WLSEL<376>	WLSEL<376>
// WLSEL<377>	WLSEL<377>
// WLSEL<378>	WLSEL<378>
// WLSEL<379>	WLSEL<379>
// WLSEL<380>	WLSEL<380>
// WLSEL<381>	WLSEL<381>
// WLSEL<382>	WLSEL<382>
// WLSEL<383>	WLSEL<383>
// SEL1<11>	SEL1<11>
// WLSEL<384>	WLSEL<384>
// WLSEL<385>	WLSEL<385>
// WLSEL<386>	WLSEL<386>
// WLSEL<387>	WLSEL<387>
// WLSEL<388>	WLSEL<388>
// WLSEL<389>	WLSEL<389>
// WLSEL<390>	WLSEL<390>
// WLSEL<391>	WLSEL<391>
// WLSEL<392>	WLSEL<392>
// WLSEL<393>	WLSEL<393>
// WLSEL<394>	WLSEL<394>
// WLSEL<395>	WLSEL<395>
// WLSEL<396>	WLSEL<396>
// WLSEL<397>	WLSEL<397>
// WLSEL<398>	WLSEL<398>
// WLSEL<399>	WLSEL<399>
// WLSEL<400>	WLSEL<400>
// WLSEL<401>	WLSEL<401>
// WLSEL<402>	WLSEL<402>
// WLSEL<403>	WLSEL<403>
// WLSEL<404>	WLSEL<404>
// WLSEL<405>	WLSEL<405>
// WLSEL<406>	WLSEL<406>
// WLSEL<407>	WLSEL<407>
// WLSEL<408>	WLSEL<408>
// WLSEL<409>	WLSEL<409>
// WLSEL<410>	WLSEL<410>
// WLSEL<411>	WLSEL<411>
// WLSEL<412>	WLSEL<412>
// WLSEL<413>	WLSEL<413>
// WLSEL<414>	WLSEL<414>
// WLSEL<415>	WLSEL<415>
// SEL1<12>	SEL1<12>
// WLSEL<416>	WLSEL<416>
// WLSEL<417>	WLSEL<417>
// WLSEL<418>	WLSEL<418>
// WLSEL<419>	WLSEL<419>
// WLSEL<420>	WLSEL<420>
// WLSEL<421>	WLSEL<421>
// WLSEL<422>	WLSEL<422>
// WLSEL<423>	WLSEL<423>
// WLSEL<424>	WLSEL<424>
// WLSEL<425>	WLSEL<425>
// WLSEL<426>	WLSEL<426>
// WLSEL<427>	WLSEL<427>
// WLSEL<428>	WLSEL<428>
// WLSEL<429>	WLSEL<429>
// WLSEL<430>	WLSEL<430>
// WLSEL<431>	WLSEL<431>
// WLSEL<432>	WLSEL<432>
// WLSEL<433>	WLSEL<433>
// WLSEL<434>	WLSEL<434>
// WLSEL<435>	WLSEL<435>
// WLSEL<436>	WLSEL<436>
// WLSEL<437>	WLSEL<437>
// WLSEL<438>	WLSEL<438>
// WLSEL<439>	WLSEL<439>
// WLSEL<440>	WLSEL<440>
// WLSEL<441>	WLSEL<441>
// WLSEL<442>	WLSEL<442>
// WLSEL<443>	WLSEL<443>
// WLSEL<444>	WLSEL<444>
// WLSEL<445>	WLSEL<445>
// WLSEL<446>	WLSEL<446>
// WLSEL<447>	WLSEL<447>
// SEL1<13>	SEL1<13>
// WLSEL<448>	WLSEL<448>
// WLSEL<449>	WLSEL<449>
// WLSEL<450>	WLSEL<450>
// WLSEL<451>	WLSEL<451>
// WLSEL<452>	WLSEL<452>
// WLSEL<453>	WLSEL<453>
// WLSEL<454>	WLSEL<454>
// WLSEL<455>	WLSEL<455>
// WLSEL<456>	WLSEL<456>
// WLSEL<457>	WLSEL<457>
// WLSEL<458>	WLSEL<458>
// WLSEL<459>	WLSEL<459>
// WLSEL<460>	WLSEL<460>
// WLSEL<461>	WLSEL<461>
// WLSEL<462>	WLSEL<462>
// WLSEL<463>	WLSEL<463>
// WLSEL<464>	WLSEL<464>
// WLSEL<465>	WLSEL<465>
// WLSEL<466>	WLSEL<466>
// WLSEL<467>	WLSEL<467>
// WLSEL<468>	WLSEL<468>
// WLSEL<469>	WLSEL<469>
// WLSEL<470>	WLSEL<470>
// WLSEL<471>	WLSEL<471>
// WLSEL<472>	WLSEL<472>
// WLSEL<473>	WLSEL<473>
// WLSEL<474>	WLSEL<474>
// WLSEL<475>	WLSEL<475>
// WLSEL<476>	WLSEL<476>
// WLSEL<477>	WLSEL<477>
// WLSEL<478>	WLSEL<478>
// WLSEL<479>	WLSEL<479>
// SEL1<14>	SEL1<14>
// WLSEL<480>	WLSEL<480>
// SEL0<0>	SEL0<0>
// WLSEL<481>	WLSEL<481>
// WLSEL<482>	WLSEL<482>
// SEL0<1>	SEL0<1>
// WLSEL<483>	WLSEL<483>
// WLSEL<484>	WLSEL<484>
// SEL0<2>	SEL0<2>
// WLSEL<485>	WLSEL<485>
// WLSEL<486>	WLSEL<486>
// SEL0<3>	SEL0<3>
// WLSEL<487>	WLSEL<487>
// WLSEL<488>	WLSEL<488>
// SEL0<4>	SEL0<4>
// WLSEL<489>	WLSEL<489>
// WLSEL<490>	WLSEL<490>
// SEL0<5>	SEL0<5>
// WLSEL<491>	WLSEL<491>
// WLSEL<492>	WLSEL<492>
// SEL0<6>	SEL0<6>
// WLSEL<493>	WLSEL<493>
// WLSEL<494>	WLSEL<494>
// SEL0<7>	SEL0<7>
// WLSEL<495>	WLSEL<495>
// WLSEL<496>	WLSEL<496>
// SEL0<8>	SEL0<8>
// WLSEL<497>	WLSEL<497>
// WLSEL<498>	WLSEL<498>
// SEL0<9>	SEL0<9>
// WLSEL<499>	WLSEL<499>
// WLSEL<500>	WLSEL<500>
// SEL0<10>	SEL0<10>
// WLSEL<501>	WLSEL<501>
// WLSEL<502>	WLSEL<502>
// SEL0<11>	SEL0<11>
// WLSEL<503>	WLSEL<503>
// WLSEL<504>	WLSEL<504>
// SEL0<12>	SEL0<12>
// WLSEL<505>	WLSEL<505>
// WLSEL<506>	WLSEL<506>
// SEL0<13>	SEL0<13>
// WLSEL<507>	WLSEL<507>
// WLSEL<508>	WLSEL<508>
// SEL0<14>	SEL0<14>
// WLSEL<509>	WLSEL<509>
// WLSEL<510>	WLSEL<510>
// SEL0<15>	SEL0<15>
// WLSEL<511>	WLSEL<511>
// SEL1<15>	SEL1<15>
XXI2\<15\>\/XI2\<15\>\/RR1 (  N_SEL1\<15\>_XI2\<15\>\/XI2\<15\>\/RR1_pos \
 N_WLSEL\<511\>_XI2\<15\>\/XI2\<15\>\/RR1_neg ) R_1X_LL w=1e-07 l=1e-07   \
 res=0.149966
XXI2\<15\>\/XI2\<15\>\/RR0 (  N_SEL0\<15\>_XI2\<15\>\/XI2\<15\>\/RR0_pos \
 N_WLSEL\<510\>_XI2\<15\>\/XI2\<15\>\/RR0_neg ) R_1X_LL w=1e-07 l=1e-07   \
 res=0.149966
XXI2\<15\>\/XI2\<14\>\/RR1 (  N_SEL1\<15\>_XI2\<15\>\/XI2\<14\>\/RR1_pos \
 N_WLSEL\<509\>_XI2\<15\>\/XI2\<14\>\/RR1_neg ) R_1X_LL w=1e-07 l=1e-07   \
 res=0.149966
XXI2\<15\>\/XI2\<14\>\/RR0 (  N_SEL0\<14\>_XI2\<15\>\/XI2\<14\>\/RR0_pos \
 N_WLSEL\<508\>_XI2\<15\>\/XI2\<14\>\/RR0_neg ) R_1X_LL w=1e-07 l=1e-07   \
 res=0.149966
XXI2\<15\>\/XI2\<13\>\/RR1 (  N_SEL1\<15\>_XI2\<15\>\/XI2\<13\>\/RR1_pos \
 N_WLSEL\<507\>_XI2\<15\>\/XI2\<13\>\/RR1_neg ) R_1X_LL w=1e-07 l=1e-07   \
 res=0.149966
XXI2\<15\>\/XI2\<13\>\/RR0 (  N_SEL0\<13\>_XI2\<15\>\/XI2\<13\>\/RR0_pos \
 N_WLSEL\<506\>_XI2\<15\>\/XI2\<13\>\/RR0_neg ) R_1X_LL w=1e-07 l=1e-07   \
 res=0.149966
XXI2\<15\>\/XI2\<12\>\/RR1 (  N_SEL1\<15\>_XI2\<15\>\/XI2\<12\>\/RR1_pos \
 N_WLSEL\<505\>_XI2\<15\>\/XI2\<12\>\/RR1_neg ) R_1X_LL w=1e-07 l=1e-07   \
 res=0.149966
XXI2\<15\>\/XI2\<12\>\/RR0 (  N_SEL0\<12\>_XI2\<15\>\/XI2\<12\>\/RR0_pos \
 N_WLSEL\<504\>_XI2\<15\>\/XI2\<12\>\/RR0_neg ) R_1X_LL w=1e-07 l=1e-07   \
 res=0.149966
XXI2\<15\>\/XI2\<11\>\/RR1 (  N_SEL1\<15\>_XI2\<15\>\/XI2\<11\>\/RR1_pos \
 N_WLSEL\<503\>_XI2\<15\>\/XI2\<11\>\/RR1_neg ) R_1X_LL w=1e-07 l=1e-07   \
 res=0.149966
XXI2\<15\>\/XI2\<11\>\/RR0 (  N_SEL0\<11\>_XI2\<15\>\/XI2\<11\>\/RR0_pos \
 N_WLSEL\<502\>_XI2\<15\>\/XI2\<11\>\/RR0_neg ) R_1X_LL w=1e-07 l=1e-07   \
 res=0.149966
XXI2\<15\>\/XI2\<10\>\/RR1 (  N_SEL1\<15\>_XI2\<15\>\/XI2\<10\>\/RR1_pos \
 N_WLSEL\<501\>_XI2\<15\>\/XI2\<10\>\/RR1_neg ) R_1X_LL w=1e-07 l=1e-07   \
 res=0.149966
XXI2\<15\>\/XI2\<10\>\/RR0 (  N_SEL0\<10\>_XI2\<15\>\/XI2\<10\>\/RR0_pos \
 N_WLSEL\<500\>_XI2\<15\>\/XI2\<10\>\/RR0_neg ) R_1X_LL w=1e-07 l=1e-07   \
 res=0.149966
XXI2\<15\>\/XI2\<9\>\/RR1 (  N_SEL1\<15\>_XI2\<15\>\/XI2\<9\>\/RR1_pos \
 N_WLSEL\<499\>_XI2\<15\>\/XI2\<9\>\/RR1_neg ) R_1X_LL w=1e-07 l=1e-07   \
 res=0.149966
XXI2\<15\>\/XI2\<9\>\/RR0 (  N_SEL0\<9\>_XI2\<15\>\/XI2\<9\>\/RR0_pos \
 N_WLSEL\<498\>_XI2\<15\>\/XI2\<9\>\/RR0_neg ) R_1X_LL w=1e-07 l=1e-07   \
 res=0.149966
XXI2\<15\>\/XI2\<8\>\/RR1 (  N_SEL1\<15\>_XI2\<15\>\/XI2\<8\>\/RR1_pos \
 N_WLSEL\<497\>_XI2\<15\>\/XI2\<8\>\/RR1_neg ) R_1X_LL w=1e-07 l=1e-07   \
 res=0.149966
XXI2\<15\>\/XI2\<8\>\/RR0 (  N_SEL0\<8\>_XI2\<15\>\/XI2\<8\>\/RR0_pos \
 N_WLSEL\<496\>_XI2\<15\>\/XI2\<8\>\/RR0_neg ) R_1X_LL w=1e-07 l=1e-07   \
 res=0.149966
XXI2\<15\>\/XI2\<7\>\/RR1 (  N_SEL1\<15\>_XI2\<15\>\/XI2\<7\>\/RR1_pos \
 N_WLSEL\<495\>_XI2\<15\>\/XI2\<7\>\/RR1_neg ) R_1X_LL w=1e-07 l=1e-07   \
 res=0.149966
XXI2\<15\>\/XI2\<7\>\/RR0 (  N_SEL0\<7\>_XI2\<15\>\/XI2\<7\>\/RR0_pos \
 N_WLSEL\<494\>_XI2\<15\>\/XI2\<7\>\/RR0_neg ) R_1X_LL w=1e-07 l=1e-07   \
 res=0.149966
XXI2\<15\>\/XI2\<6\>\/RR1 (  N_SEL1\<15\>_XI2\<15\>\/XI2\<6\>\/RR1_pos \
 N_WLSEL\<493\>_XI2\<15\>\/XI2\<6\>\/RR1_neg ) R_1X_LL w=1e-07 l=1e-07   \
 res=0.149966
XXI2\<15\>\/XI2\<6\>\/RR0 (  N_SEL0\<6\>_XI2\<15\>\/XI2\<6\>\/RR0_pos \
 N_WLSEL\<492\>_XI2\<15\>\/XI2\<6\>\/RR0_neg ) R_1X_LL w=1e-07 l=1e-07   \
 res=0.149966
XXI2\<15\>\/XI2\<5\>\/RR1 (  N_SEL1\<15\>_XI2\<15\>\/XI2\<5\>\/RR1_pos \
 N_WLSEL\<491\>_XI2\<15\>\/XI2\<5\>\/RR1_neg ) R_1X_LL w=1e-07 l=1e-07   \
 res=0.149966
XXI2\<15\>\/XI2\<5\>\/RR0 (  N_SEL0\<5\>_XI2\<15\>\/XI2\<5\>\/RR0_pos \
 N_WLSEL\<490\>_XI2\<15\>\/XI2\<5\>\/RR0_neg ) R_1X_LL w=1e-07 l=1e-07   \
 res=0.149966
XXI2\<15\>\/XI2\<4\>\/RR1 (  N_SEL1\<15\>_XI2\<15\>\/XI2\<4\>\/RR1_pos \
 N_WLSEL\<489\>_XI2\<15\>\/XI2\<4\>\/RR1_neg ) R_1X_LL w=1e-07 l=1e-07   \
 res=0.149966
XXI2\<15\>\/XI2\<4\>\/RR0 (  N_SEL0\<4\>_XI2\<15\>\/XI2\<4\>\/RR0_pos \
 N_WLSEL\<488\>_XI2\<15\>\/XI2\<4\>\/RR0_neg ) R_1X_LL w=1e-07 l=1e-07   \
 res=0.149966
XXI2\<15\>\/XI2\<3\>\/RR1 (  N_SEL1\<15\>_XI2\<15\>\/XI2\<3\>\/RR1_pos \
 N_WLSEL\<487\>_XI2\<15\>\/XI2\<3\>\/RR1_neg ) R_1X_LL w=1e-07 l=1e-07   \
 res=0.149966
XXI2\<15\>\/XI2\<3\>\/RR0 (  N_SEL0\<3\>_XI2\<15\>\/XI2\<3\>\/RR0_pos \
 N_WLSEL\<486\>_XI2\<15\>\/XI2\<3\>\/RR0_neg ) R_1X_LL w=1e-07 l=1e-07   \
 res=0.149966
XXI2\<15\>\/XI2\<2\>\/RR1 (  N_SEL1\<15\>_XI2\<15\>\/XI2\<2\>\/RR1_pos \
 N_WLSEL\<485\>_XI2\<15\>\/XI2\<2\>\/RR1_neg ) R_1X_LL w=1e-07 l=1e-07   \
 res=0.149966
XXI2\<15\>\/XI2\<2\>\/RR0 (  N_SEL0\<2\>_XI2\<15\>\/XI2\<2\>\/RR0_pos \
 N_WLSEL\<484\>_XI2\<15\>\/XI2\<2\>\/RR0_neg ) R_1X_LL w=1e-07 l=1e-07   \
 res=0.149966
XXI2\<15\>\/XI2\<1\>\/RR1 (  N_SEL1\<15\>_XI2\<15\>\/XI2\<1\>\/RR1_pos \
 N_WLSEL\<483\>_XI2\<15\>\/XI2\<1\>\/RR1_neg ) R_1X_LL w=1e-07 l=1e-07   \
 res=0.149966
XXI2\<15\>\/XI2\<1\>\/RR0 (  N_SEL0\<1\>_XI2\<15\>\/XI2\<1\>\/RR0_pos \
 N_WLSEL\<482\>_XI2\<15\>\/XI2\<1\>\/RR0_neg ) R_1X_LL w=1e-07 l=1e-07   \
 res=0.149966
XXI2\<15\>\/XI2\<0\>\/RR1 (  N_SEL1\<15\>_XI2\<15\>\/XI2\<0\>\/RR1_pos \
 N_WLSEL\<481\>_XI2\<15\>\/XI2\<0\>\/RR1_neg ) R_1X_LL w=1e-07 l=1e-07   \
 res=0.149966
XXI2\<15\>\/XI2\<0\>\/RR0 (  N_SEL0\<0\>_XI2\<15\>\/XI2\<0\>\/RR0_pos \
 N_WLSEL\<480\>_XI2\<15\>\/XI2\<0\>\/RR0_neg ) R_1X_LL w=1e-07 l=1e-07   \
 res=0.149966
XXI2\<14\>\/XI2\<15\>\/RR1 (  N_SEL1\<14\>_XI2\<14\>\/XI2\<15\>\/RR1_pos \
 N_WLSEL\<479\>_XI2\<14\>\/XI2\<15\>\/RR1_neg ) R_1X_LL w=1e-07 l=1e-07   \
 res=0.149966
XXI2\<14\>\/XI2\<15\>\/RR0 (  N_SEL0\<15\>_XI2\<14\>\/XI2\<15\>\/RR0_pos \
 N_WLSEL\<478\>_XI2\<14\>\/XI2\<15\>\/RR0_neg ) R_1X_LL w=1e-07 l=1e-07   \
 res=0.149966
XXI2\<14\>\/XI2\<14\>\/RR1 (  N_SEL1\<14\>_XI2\<14\>\/XI2\<14\>\/RR1_pos \
 N_WLSEL\<477\>_XI2\<14\>\/XI2\<14\>\/RR1_neg ) R_1X_LL w=1e-07 l=1e-07   \
 res=0.149966
XXI2\<14\>\/XI2\<14\>\/RR0 (  N_SEL0\<14\>_XI2\<14\>\/XI2\<14\>\/RR0_pos \
 N_WLSEL\<476\>_XI2\<14\>\/XI2\<14\>\/RR0_neg ) R_1X_LL w=1e-07 l=1e-07   \
 res=0.149966
XXI2\<14\>\/XI2\<13\>\/RR1 (  N_SEL1\<14\>_XI2\<14\>\/XI2\<13\>\/RR1_pos \
 N_WLSEL\<475\>_XI2\<14\>\/XI2\<13\>\/RR1_neg ) R_1X_LL w=1e-07 l=1e-07   \
 res=0.149966
XXI2\<14\>\/XI2\<13\>\/RR0 (  N_SEL0\<13\>_XI2\<14\>\/XI2\<13\>\/RR0_pos \
 N_WLSEL\<474\>_XI2\<14\>\/XI2\<13\>\/RR0_neg ) R_1X_LL w=1e-07 l=1e-07   \
 res=0.149966
XXI2\<14\>\/XI2\<12\>\/RR1 (  N_SEL1\<14\>_XI2\<14\>\/XI2\<12\>\/RR1_pos \
 N_WLSEL\<473\>_XI2\<14\>\/XI2\<12\>\/RR1_neg ) R_1X_LL w=1e-07 l=1e-07   \
 res=0.149966
XXI2\<14\>\/XI2\<12\>\/RR0 (  N_SEL0\<12\>_XI2\<14\>\/XI2\<12\>\/RR0_pos \
 N_WLSEL\<472\>_XI2\<14\>\/XI2\<12\>\/RR0_neg ) R_1X_LL w=1e-07 l=1e-07   \
 res=0.149966
XXI2\<14\>\/XI2\<11\>\/RR1 (  N_SEL1\<14\>_XI2\<14\>\/XI2\<11\>\/RR1_pos \
 N_WLSEL\<471\>_XI2\<14\>\/XI2\<11\>\/RR1_neg ) R_1X_LL w=1e-07 l=1e-07   \
 res=0.149966
XXI2\<14\>\/XI2\<11\>\/RR0 (  N_SEL0\<11\>_XI2\<14\>\/XI2\<11\>\/RR0_pos \
 N_WLSEL\<470\>_XI2\<14\>\/XI2\<11\>\/RR0_neg ) R_1X_LL w=1e-07 l=1e-07   \
 res=0.149966
XXI2\<14\>\/XI2\<10\>\/RR1 (  N_SEL1\<14\>_XI2\<14\>\/XI2\<10\>\/RR1_pos \
 N_WLSEL\<469\>_XI2\<14\>\/XI2\<10\>\/RR1_neg ) R_1X_LL w=1e-07 l=1e-07   \
 res=0.149966
XXI2\<14\>\/XI2\<10\>\/RR0 (  N_SEL0\<10\>_XI2\<14\>\/XI2\<10\>\/RR0_pos \
 N_WLSEL\<468\>_XI2\<14\>\/XI2\<10\>\/RR0_neg ) R_1X_LL w=1e-07 l=1e-07   \
 res=0.149966
XXI2\<14\>\/XI2\<9\>\/RR1 (  N_SEL1\<14\>_XI2\<14\>\/XI2\<9\>\/RR1_pos \
 N_WLSEL\<467\>_XI2\<14\>\/XI2\<9\>\/RR1_neg ) R_1X_LL w=1e-07 l=1e-07   \
 res=0.149966
XXI2\<14\>\/XI2\<9\>\/RR0 (  N_SEL0\<9\>_XI2\<14\>\/XI2\<9\>\/RR0_pos \
 N_WLSEL\<466\>_XI2\<14\>\/XI2\<9\>\/RR0_neg ) R_1X_LL w=1e-07 l=1e-07   \
 res=0.149966
XXI2\<14\>\/XI2\<8\>\/RR1 (  N_SEL1\<14\>_XI2\<14\>\/XI2\<8\>\/RR1_pos \
 N_WLSEL\<465\>_XI2\<14\>\/XI2\<8\>\/RR1_neg ) R_1X_LL w=1e-07 l=1e-07   \
 res=0.149966
XXI2\<14\>\/XI2\<8\>\/RR0 (  N_SEL0\<8\>_XI2\<14\>\/XI2\<8\>\/RR0_pos \
 N_WLSEL\<464\>_XI2\<14\>\/XI2\<8\>\/RR0_neg ) R_1X_LL w=1e-07 l=1e-07   \
 res=0.149966
XXI2\<14\>\/XI2\<7\>\/RR1 (  N_SEL1\<14\>_XI2\<14\>\/XI2\<7\>\/RR1_pos \
 N_WLSEL\<463\>_XI2\<14\>\/XI2\<7\>\/RR1_neg ) R_1X_LL w=1e-07 l=1e-07   \
 res=0.149966
XXI2\<14\>\/XI2\<7\>\/RR0 (  N_SEL0\<7\>_XI2\<14\>\/XI2\<7\>\/RR0_pos \
 N_WLSEL\<462\>_XI2\<14\>\/XI2\<7\>\/RR0_neg ) R_1X_LL w=1e-07 l=1e-07   \
 res=0.149966
XXI2\<14\>\/XI2\<6\>\/RR1 (  N_SEL1\<14\>_XI2\<14\>\/XI2\<6\>\/RR1_pos \
 N_WLSEL\<461\>_XI2\<14\>\/XI2\<6\>\/RR1_neg ) R_1X_LL w=1e-07 l=1e-07   \
 res=0.149966
XXI2\<14\>\/XI2\<6\>\/RR0 (  N_SEL0\<6\>_XI2\<14\>\/XI2\<6\>\/RR0_pos \
 N_WLSEL\<460\>_XI2\<14\>\/XI2\<6\>\/RR0_neg ) R_1X_LL w=1e-07 l=1e-07   \
 res=0.149966
XXI2\<14\>\/XI2\<5\>\/RR1 (  N_SEL1\<14\>_XI2\<14\>\/XI2\<5\>\/RR1_pos \
 N_WLSEL\<459\>_XI2\<14\>\/XI2\<5\>\/RR1_neg ) R_1X_LL w=1e-07 l=1e-07   \
 res=0.149966
XXI2\<14\>\/XI2\<5\>\/RR0 (  N_SEL0\<5\>_XI2\<14\>\/XI2\<5\>\/RR0_pos \
 N_WLSEL\<458\>_XI2\<14\>\/XI2\<5\>\/RR0_neg ) R_1X_LL w=1e-07 l=1e-07   \
 res=0.149966
XXI2\<14\>\/XI2\<4\>\/RR1 (  N_SEL1\<14\>_XI2\<14\>\/XI2\<4\>\/RR1_pos \
 N_WLSEL\<457\>_XI2\<14\>\/XI2\<4\>\/RR1_neg ) R_1X_LL w=1e-07 l=1e-07   \
 res=0.149966
XXI2\<14\>\/XI2\<4\>\/RR0 (  N_SEL0\<4\>_XI2\<14\>\/XI2\<4\>\/RR0_pos \
 N_WLSEL\<456\>_XI2\<14\>\/XI2\<4\>\/RR0_neg ) R_1X_LL w=1e-07 l=1e-07   \
 res=0.149966
XXI2\<14\>\/XI2\<3\>\/RR1 (  N_SEL1\<14\>_XI2\<14\>\/XI2\<3\>\/RR1_pos \
 N_WLSEL\<455\>_XI2\<14\>\/XI2\<3\>\/RR1_neg ) R_1X_LL w=1e-07 l=1e-07   \
 res=0.149966
XXI2\<14\>\/XI2\<3\>\/RR0 (  N_SEL0\<3\>_XI2\<14\>\/XI2\<3\>\/RR0_pos \
 N_WLSEL\<454\>_XI2\<14\>\/XI2\<3\>\/RR0_neg ) R_1X_LL w=1e-07 l=1e-07   \
 res=0.149966
XXI2\<14\>\/XI2\<2\>\/RR1 (  N_SEL1\<14\>_XI2\<14\>\/XI2\<2\>\/RR1_pos \
 N_WLSEL\<453\>_XI2\<14\>\/XI2\<2\>\/RR1_neg ) R_1X_LL w=1e-07 l=1e-07   \
 res=0.149966
XXI2\<14\>\/XI2\<2\>\/RR0 (  N_SEL0\<2\>_XI2\<14\>\/XI2\<2\>\/RR0_pos \
 N_WLSEL\<452\>_XI2\<14\>\/XI2\<2\>\/RR0_neg ) R_1X_LL w=1e-07 l=1e-07   \
 res=0.149966
XXI2\<14\>\/XI2\<1\>\/RR1 (  N_SEL1\<14\>_XI2\<14\>\/XI2\<1\>\/RR1_pos \
 N_WLSEL\<451\>_XI2\<14\>\/XI2\<1\>\/RR1_neg ) R_1X_LL w=1e-07 l=1e-07   \
 res=0.149966
XXI2\<14\>\/XI2\<1\>\/RR0 (  N_SEL0\<1\>_XI2\<14\>\/XI2\<1\>\/RR0_pos \
 N_WLSEL\<450\>_XI2\<14\>\/XI2\<1\>\/RR0_neg ) R_1X_LL w=1e-07 l=1e-07   \
 res=0.149966
XXI2\<14\>\/XI2\<0\>\/RR1 (  N_SEL1\<14\>_XI2\<14\>\/XI2\<0\>\/RR1_pos \
 N_WLSEL\<449\>_XI2\<14\>\/XI2\<0\>\/RR1_neg ) R_1X_LL w=1e-07 l=1e-07   \
 res=0.149966
XXI2\<14\>\/XI2\<0\>\/RR0 (  N_SEL0\<0\>_XI2\<14\>\/XI2\<0\>\/RR0_pos \
 N_WLSEL\<448\>_XI2\<14\>\/XI2\<0\>\/RR0_neg ) R_1X_LL w=1e-07 l=1e-07   \
 res=0.149966
XXI2\<13\>\/XI2\<15\>\/RR1 (  N_SEL1\<13\>_XI2\<13\>\/XI2\<15\>\/RR1_pos \
 N_WLSEL\<447\>_XI2\<13\>\/XI2\<15\>\/RR1_neg ) R_1X_LL w=1e-07 l=1e-07   \
 res=0.149966
XXI2\<13\>\/XI2\<15\>\/RR0 (  N_SEL0\<15\>_XI2\<13\>\/XI2\<15\>\/RR0_pos \
 N_WLSEL\<446\>_XI2\<13\>\/XI2\<15\>\/RR0_neg ) R_1X_LL w=1e-07 l=1e-07   \
 res=0.149966
XXI2\<13\>\/XI2\<14\>\/RR1 (  N_SEL1\<13\>_XI2\<13\>\/XI2\<14\>\/RR1_pos \
 N_WLSEL\<445\>_XI2\<13\>\/XI2\<14\>\/RR1_neg ) R_1X_LL w=1e-07 l=1e-07   \
 res=0.149966
XXI2\<13\>\/XI2\<14\>\/RR0 (  N_SEL0\<14\>_XI2\<13\>\/XI2\<14\>\/RR0_pos \
 N_WLSEL\<444\>_XI2\<13\>\/XI2\<14\>\/RR0_neg ) R_1X_LL w=1e-07 l=1e-07   \
 res=0.149966
XXI2\<13\>\/XI2\<13\>\/RR1 (  N_SEL1\<13\>_XI2\<13\>\/XI2\<13\>\/RR1_pos \
 N_WLSEL\<443\>_XI2\<13\>\/XI2\<13\>\/RR1_neg ) R_1X_LL w=1e-07 l=1e-07   \
 res=0.149966
XXI2\<13\>\/XI2\<13\>\/RR0 (  N_SEL0\<13\>_XI2\<13\>\/XI2\<13\>\/RR0_pos \
 N_WLSEL\<442\>_XI2\<13\>\/XI2\<13\>\/RR0_neg ) R_1X_LL w=1e-07 l=1e-07   \
 res=0.149966
XXI2\<13\>\/XI2\<12\>\/RR1 (  N_SEL1\<13\>_XI2\<13\>\/XI2\<12\>\/RR1_pos \
 N_WLSEL\<441\>_XI2\<13\>\/XI2\<12\>\/RR1_neg ) R_1X_LL w=1e-07 l=1e-07   \
 res=0.149966
XXI2\<13\>\/XI2\<12\>\/RR0 (  N_SEL0\<12\>_XI2\<13\>\/XI2\<12\>\/RR0_pos \
 N_WLSEL\<440\>_XI2\<13\>\/XI2\<12\>\/RR0_neg ) R_1X_LL w=1e-07 l=1e-07   \
 res=0.149966
XXI2\<13\>\/XI2\<11\>\/RR1 (  N_SEL1\<13\>_XI2\<13\>\/XI2\<11\>\/RR1_pos \
 N_WLSEL\<439\>_XI2\<13\>\/XI2\<11\>\/RR1_neg ) R_1X_LL w=1e-07 l=1e-07   \
 res=0.149966
XXI2\<13\>\/XI2\<11\>\/RR0 (  N_SEL0\<11\>_XI2\<13\>\/XI2\<11\>\/RR0_pos \
 N_WLSEL\<438\>_XI2\<13\>\/XI2\<11\>\/RR0_neg ) R_1X_LL w=1e-07 l=1e-07   \
 res=0.149966
XXI2\<13\>\/XI2\<10\>\/RR1 (  N_SEL1\<13\>_XI2\<13\>\/XI2\<10\>\/RR1_pos \
 N_WLSEL\<437\>_XI2\<13\>\/XI2\<10\>\/RR1_neg ) R_1X_LL w=1e-07 l=1e-07   \
 res=0.149966
XXI2\<13\>\/XI2\<10\>\/RR0 (  N_SEL0\<10\>_XI2\<13\>\/XI2\<10\>\/RR0_pos \
 N_WLSEL\<436\>_XI2\<13\>\/XI2\<10\>\/RR0_neg ) R_1X_LL w=1e-07 l=1e-07   \
 res=0.149966
XXI2\<13\>\/XI2\<9\>\/RR1 (  N_SEL1\<13\>_XI2\<13\>\/XI2\<9\>\/RR1_pos \
 N_WLSEL\<435\>_XI2\<13\>\/XI2\<9\>\/RR1_neg ) R_1X_LL w=1e-07 l=1e-07   \
 res=0.149966
XXI2\<13\>\/XI2\<9\>\/RR0 (  N_SEL0\<9\>_XI2\<13\>\/XI2\<9\>\/RR0_pos \
 N_WLSEL\<434\>_XI2\<13\>\/XI2\<9\>\/RR0_neg ) R_1X_LL w=1e-07 l=1e-07   \
 res=0.149966
XXI2\<13\>\/XI2\<8\>\/RR1 (  N_SEL1\<13\>_XI2\<13\>\/XI2\<8\>\/RR1_pos \
 N_WLSEL\<433\>_XI2\<13\>\/XI2\<8\>\/RR1_neg ) R_1X_LL w=1e-07 l=1e-07   \
 res=0.149966
XXI2\<13\>\/XI2\<8\>\/RR0 (  N_SEL0\<8\>_XI2\<13\>\/XI2\<8\>\/RR0_pos \
 N_WLSEL\<432\>_XI2\<13\>\/XI2\<8\>\/RR0_neg ) R_1X_LL w=1e-07 l=1e-07   \
 res=0.149966
XXI2\<13\>\/XI2\<7\>\/RR1 (  N_SEL1\<13\>_XI2\<13\>\/XI2\<7\>\/RR1_pos \
 N_WLSEL\<431\>_XI2\<13\>\/XI2\<7\>\/RR1_neg ) R_1X_LL w=1e-07 l=1e-07   \
 res=0.149966
XXI2\<13\>\/XI2\<7\>\/RR0 (  N_SEL0\<7\>_XI2\<13\>\/XI2\<7\>\/RR0_pos \
 N_WLSEL\<430\>_XI2\<13\>\/XI2\<7\>\/RR0_neg ) R_1X_LL w=1e-07 l=1e-07   \
 res=0.149966
XXI2\<13\>\/XI2\<6\>\/RR1 (  N_SEL1\<13\>_XI2\<13\>\/XI2\<6\>\/RR1_pos \
 N_WLSEL\<429\>_XI2\<13\>\/XI2\<6\>\/RR1_neg ) R_1X_LL w=1e-07 l=1e-07   \
 res=0.149966
XXI2\<13\>\/XI2\<6\>\/RR0 (  N_SEL0\<6\>_XI2\<13\>\/XI2\<6\>\/RR0_pos \
 N_WLSEL\<428\>_XI2\<13\>\/XI2\<6\>\/RR0_neg ) R_1X_LL w=1e-07 l=1e-07   \
 res=0.149966
XXI2\<13\>\/XI2\<5\>\/RR1 (  N_SEL1\<13\>_XI2\<13\>\/XI2\<5\>\/RR1_pos \
 N_WLSEL\<427\>_XI2\<13\>\/XI2\<5\>\/RR1_neg ) R_1X_LL w=1e-07 l=1e-07   \
 res=0.149966
XXI2\<13\>\/XI2\<5\>\/RR0 (  N_SEL0\<5\>_XI2\<13\>\/XI2\<5\>\/RR0_pos \
 N_WLSEL\<426\>_XI2\<13\>\/XI2\<5\>\/RR0_neg ) R_1X_LL w=1e-07 l=1e-07   \
 res=0.149966
XXI2\<13\>\/XI2\<4\>\/RR1 (  N_SEL1\<13\>_XI2\<13\>\/XI2\<4\>\/RR1_pos \
 N_WLSEL\<425\>_XI2\<13\>\/XI2\<4\>\/RR1_neg ) R_1X_LL w=1e-07 l=1e-07   \
 res=0.149966
XXI2\<13\>\/XI2\<4\>\/RR0 (  N_SEL0\<4\>_XI2\<13\>\/XI2\<4\>\/RR0_pos \
 N_WLSEL\<424\>_XI2\<13\>\/XI2\<4\>\/RR0_neg ) R_1X_LL w=1e-07 l=1e-07   \
 res=0.149966
XXI2\<13\>\/XI2\<3\>\/RR1 (  N_SEL1\<13\>_XI2\<13\>\/XI2\<3\>\/RR1_pos \
 N_WLSEL\<423\>_XI2\<13\>\/XI2\<3\>\/RR1_neg ) R_1X_LL w=1e-07 l=1e-07   \
 res=0.149966
XXI2\<13\>\/XI2\<3\>\/RR0 (  N_SEL0\<3\>_XI2\<13\>\/XI2\<3\>\/RR0_pos \
 N_WLSEL\<422\>_XI2\<13\>\/XI2\<3\>\/RR0_neg ) R_1X_LL w=1e-07 l=1e-07   \
 res=0.149966
XXI2\<13\>\/XI2\<2\>\/RR1 (  N_SEL1\<13\>_XI2\<13\>\/XI2\<2\>\/RR1_pos \
 N_WLSEL\<421\>_XI2\<13\>\/XI2\<2\>\/RR1_neg ) R_1X_LL w=1e-07 l=1e-07   \
 res=0.149966
XXI2\<13\>\/XI2\<2\>\/RR0 (  N_SEL0\<2\>_XI2\<13\>\/XI2\<2\>\/RR0_pos \
 N_WLSEL\<420\>_XI2\<13\>\/XI2\<2\>\/RR0_neg ) R_1X_LL w=1e-07 l=1e-07   \
 res=0.149966
XXI2\<13\>\/XI2\<1\>\/RR1 (  N_SEL1\<13\>_XI2\<13\>\/XI2\<1\>\/RR1_pos \
 N_WLSEL\<419\>_XI2\<13\>\/XI2\<1\>\/RR1_neg ) R_1X_LL w=1e-07 l=1e-07   \
 res=0.149966
XXI2\<13\>\/XI2\<1\>\/RR0 (  N_SEL0\<1\>_XI2\<13\>\/XI2\<1\>\/RR0_pos \
 N_WLSEL\<418\>_XI2\<13\>\/XI2\<1\>\/RR0_neg ) R_1X_LL w=1e-07 l=1e-07   \
 res=0.149966
XXI2\<13\>\/XI2\<0\>\/RR1 (  N_SEL1\<13\>_XI2\<13\>\/XI2\<0\>\/RR1_pos \
 N_WLSEL\<417\>_XI2\<13\>\/XI2\<0\>\/RR1_neg ) R_1X_LL w=1e-07 l=1e-07   \
 res=0.149966
XXI2\<13\>\/XI2\<0\>\/RR0 (  N_SEL0\<0\>_XI2\<13\>\/XI2\<0\>\/RR0_pos \
 N_WLSEL\<416\>_XI2\<13\>\/XI2\<0\>\/RR0_neg ) R_1X_LL w=1e-07 l=1e-07   \
 res=0.149966
XXI2\<12\>\/XI2\<15\>\/RR1 (  N_SEL1\<12\>_XI2\<12\>\/XI2\<15\>\/RR1_pos \
 N_WLSEL\<415\>_XI2\<12\>\/XI2\<15\>\/RR1_neg ) R_1X_LL w=1e-07 l=1e-07   \
 res=0.149966
XXI2\<12\>\/XI2\<15\>\/RR0 (  N_SEL0\<15\>_XI2\<12\>\/XI2\<15\>\/RR0_pos \
 N_WLSEL\<414\>_XI2\<12\>\/XI2\<15\>\/RR0_neg ) R_1X_LL w=1e-07 l=1e-07   \
 res=0.149966
XXI2\<12\>\/XI2\<14\>\/RR1 (  N_SEL1\<12\>_XI2\<12\>\/XI2\<14\>\/RR1_pos \
 N_WLSEL\<413\>_XI2\<12\>\/XI2\<14\>\/RR1_neg ) R_1X_LL w=1e-07 l=1e-07   \
 res=0.149966
XXI2\<12\>\/XI2\<14\>\/RR0 (  N_SEL0\<14\>_XI2\<12\>\/XI2\<14\>\/RR0_pos \
 N_WLSEL\<412\>_XI2\<12\>\/XI2\<14\>\/RR0_neg ) R_1X_LL w=1e-07 l=1e-07   \
 res=0.149966
XXI2\<12\>\/XI2\<13\>\/RR1 (  N_SEL1\<12\>_XI2\<12\>\/XI2\<13\>\/RR1_pos \
 N_WLSEL\<411\>_XI2\<12\>\/XI2\<13\>\/RR1_neg ) R_1X_LL w=1e-07 l=1e-07   \
 res=0.149966
XXI2\<12\>\/XI2\<13\>\/RR0 (  N_SEL0\<13\>_XI2\<12\>\/XI2\<13\>\/RR0_pos \
 N_WLSEL\<410\>_XI2\<12\>\/XI2\<13\>\/RR0_neg ) R_1X_LL w=1e-07 l=1e-07   \
 res=0.149966
XXI2\<12\>\/XI2\<12\>\/RR1 (  N_SEL1\<12\>_XI2\<12\>\/XI2\<12\>\/RR1_pos \
 N_WLSEL\<409\>_XI2\<12\>\/XI2\<12\>\/RR1_neg ) R_1X_LL w=1e-07 l=1e-07   \
 res=0.149966
XXI2\<12\>\/XI2\<12\>\/RR0 (  N_SEL0\<12\>_XI2\<12\>\/XI2\<12\>\/RR0_pos \
 N_WLSEL\<408\>_XI2\<12\>\/XI2\<12\>\/RR0_neg ) R_1X_LL w=1e-07 l=1e-07   \
 res=0.149966
XXI2\<12\>\/XI2\<11\>\/RR1 (  N_SEL1\<12\>_XI2\<12\>\/XI2\<11\>\/RR1_pos \
 N_WLSEL\<407\>_XI2\<12\>\/XI2\<11\>\/RR1_neg ) R_1X_LL w=1e-07 l=1e-07   \
 res=0.149966
XXI2\<12\>\/XI2\<11\>\/RR0 (  N_SEL0\<11\>_XI2\<12\>\/XI2\<11\>\/RR0_pos \
 N_WLSEL\<406\>_XI2\<12\>\/XI2\<11\>\/RR0_neg ) R_1X_LL w=1e-07 l=1e-07   \
 res=0.149966
XXI2\<12\>\/XI2\<10\>\/RR1 (  N_SEL1\<12\>_XI2\<12\>\/XI2\<10\>\/RR1_pos \
 N_WLSEL\<405\>_XI2\<12\>\/XI2\<10\>\/RR1_neg ) R_1X_LL w=1e-07 l=1e-07   \
 res=0.149966
XXI2\<12\>\/XI2\<10\>\/RR0 (  N_SEL0\<10\>_XI2\<12\>\/XI2\<10\>\/RR0_pos \
 N_WLSEL\<404\>_XI2\<12\>\/XI2\<10\>\/RR0_neg ) R_1X_LL w=1e-07 l=1e-07   \
 res=0.149966
XXI2\<12\>\/XI2\<9\>\/RR1 (  N_SEL1\<12\>_XI2\<12\>\/XI2\<9\>\/RR1_pos \
 N_WLSEL\<403\>_XI2\<12\>\/XI2\<9\>\/RR1_neg ) R_1X_LL w=1e-07 l=1e-07   \
 res=0.149966
XXI2\<12\>\/XI2\<9\>\/RR0 (  N_SEL0\<9\>_XI2\<12\>\/XI2\<9\>\/RR0_pos \
 N_WLSEL\<402\>_XI2\<12\>\/XI2\<9\>\/RR0_neg ) R_1X_LL w=1e-07 l=1e-07   \
 res=0.149966
XXI2\<12\>\/XI2\<8\>\/RR1 (  N_SEL1\<12\>_XI2\<12\>\/XI2\<8\>\/RR1_pos \
 N_WLSEL\<401\>_XI2\<12\>\/XI2\<8\>\/RR1_neg ) R_1X_LL w=1e-07 l=1e-07   \
 res=0.149966
XXI2\<12\>\/XI2\<8\>\/RR0 (  N_SEL0\<8\>_XI2\<12\>\/XI2\<8\>\/RR0_pos \
 N_WLSEL\<400\>_XI2\<12\>\/XI2\<8\>\/RR0_neg ) R_1X_LL w=1e-07 l=1e-07   \
 res=0.149966
XXI2\<12\>\/XI2\<7\>\/RR1 (  N_SEL1\<12\>_XI2\<12\>\/XI2\<7\>\/RR1_pos \
 N_WLSEL\<399\>_XI2\<12\>\/XI2\<7\>\/RR1_neg ) R_1X_LL w=1e-07 l=1e-07   \
 res=0.149966
XXI2\<12\>\/XI2\<7\>\/RR0 (  N_SEL0\<7\>_XI2\<12\>\/XI2\<7\>\/RR0_pos \
 N_WLSEL\<398\>_XI2\<12\>\/XI2\<7\>\/RR0_neg ) R_1X_LL w=1e-07 l=1e-07   \
 res=0.149966
XXI2\<12\>\/XI2\<6\>\/RR1 (  N_SEL1\<12\>_XI2\<12\>\/XI2\<6\>\/RR1_pos \
 N_WLSEL\<397\>_XI2\<12\>\/XI2\<6\>\/RR1_neg ) R_1X_LL w=1e-07 l=1e-07   \
 res=0.149966
XXI2\<12\>\/XI2\<6\>\/RR0 (  N_SEL0\<6\>_XI2\<12\>\/XI2\<6\>\/RR0_pos \
 N_WLSEL\<396\>_XI2\<12\>\/XI2\<6\>\/RR0_neg ) R_1X_LL w=1e-07 l=1e-07   \
 res=0.149966
XXI2\<12\>\/XI2\<5\>\/RR1 (  N_SEL1\<12\>_XI2\<12\>\/XI2\<5\>\/RR1_pos \
 N_WLSEL\<395\>_XI2\<12\>\/XI2\<5\>\/RR1_neg ) R_1X_LL w=1e-07 l=1e-07   \
 res=0.149966
XXI2\<12\>\/XI2\<5\>\/RR0 (  N_SEL0\<5\>_XI2\<12\>\/XI2\<5\>\/RR0_pos \
 N_WLSEL\<394\>_XI2\<12\>\/XI2\<5\>\/RR0_neg ) R_1X_LL w=1e-07 l=1e-07   \
 res=0.149966
XXI2\<12\>\/XI2\<4\>\/RR1 (  N_SEL1\<12\>_XI2\<12\>\/XI2\<4\>\/RR1_pos \
 N_WLSEL\<393\>_XI2\<12\>\/XI2\<4\>\/RR1_neg ) R_1X_LL w=1e-07 l=1e-07   \
 res=0.149966
XXI2\<12\>\/XI2\<4\>\/RR0 (  N_SEL0\<4\>_XI2\<12\>\/XI2\<4\>\/RR0_pos \
 N_WLSEL\<392\>_XI2\<12\>\/XI2\<4\>\/RR0_neg ) R_1X_LL w=1e-07 l=1e-07   \
 res=0.149966
XXI2\<12\>\/XI2\<3\>\/RR1 (  N_SEL1\<12\>_XI2\<12\>\/XI2\<3\>\/RR1_pos \
 N_WLSEL\<391\>_XI2\<12\>\/XI2\<3\>\/RR1_neg ) R_1X_LL w=1e-07 l=1e-07   \
 res=0.149966
XXI2\<12\>\/XI2\<3\>\/RR0 (  N_SEL0\<3\>_XI2\<12\>\/XI2\<3\>\/RR0_pos \
 N_WLSEL\<390\>_XI2\<12\>\/XI2\<3\>\/RR0_neg ) R_1X_LL w=1e-07 l=1e-07   \
 res=0.149966
XXI2\<12\>\/XI2\<2\>\/RR1 (  N_SEL1\<12\>_XI2\<12\>\/XI2\<2\>\/RR1_pos \
 N_WLSEL\<389\>_XI2\<12\>\/XI2\<2\>\/RR1_neg ) R_1X_LL w=1e-07 l=1e-07   \
 res=0.149966
XXI2\<12\>\/XI2\<2\>\/RR0 (  N_SEL0\<2\>_XI2\<12\>\/XI2\<2\>\/RR0_pos \
 N_WLSEL\<388\>_XI2\<12\>\/XI2\<2\>\/RR0_neg ) R_1X_LL w=1e-07 l=1e-07   \
 res=0.149966
XXI2\<12\>\/XI2\<1\>\/RR1 (  N_SEL1\<12\>_XI2\<12\>\/XI2\<1\>\/RR1_pos \
 N_WLSEL\<387\>_XI2\<12\>\/XI2\<1\>\/RR1_neg ) R_1X_LL w=1e-07 l=1e-07   \
 res=0.149966
XXI2\<12\>\/XI2\<1\>\/RR0 (  N_SEL0\<1\>_XI2\<12\>\/XI2\<1\>\/RR0_pos \
 N_WLSEL\<386\>_XI2\<12\>\/XI2\<1\>\/RR0_neg ) R_1X_LL w=1e-07 l=1e-07   \
 res=0.149966
XXI2\<12\>\/XI2\<0\>\/RR1 (  N_SEL1\<12\>_XI2\<12\>\/XI2\<0\>\/RR1_pos \
 N_WLSEL\<385\>_XI2\<12\>\/XI2\<0\>\/RR1_neg ) R_1X_LL w=1e-07 l=1e-07   \
 res=0.149966
XXI2\<12\>\/XI2\<0\>\/RR0 (  N_SEL0\<0\>_XI2\<12\>\/XI2\<0\>\/RR0_pos \
 N_WLSEL\<384\>_XI2\<12\>\/XI2\<0\>\/RR0_neg ) R_1X_LL w=1e-07 l=1e-07   \
 res=0.149966
XXI2\<11\>\/XI2\<15\>\/RR1 (  N_SEL1\<11\>_XI2\<11\>\/XI2\<15\>\/RR1_pos \
 N_WLSEL\<383\>_XI2\<11\>\/XI2\<15\>\/RR1_neg ) R_1X_LL w=1e-07 l=1e-07   \
 res=0.149966
XXI2\<11\>\/XI2\<15\>\/RR0 (  N_SEL0\<15\>_XI2\<11\>\/XI2\<15\>\/RR0_pos \
 N_WLSEL\<382\>_XI2\<11\>\/XI2\<15\>\/RR0_neg ) R_1X_LL w=1e-07 l=1e-07   \
 res=0.149966
XXI2\<11\>\/XI2\<14\>\/RR1 (  N_SEL1\<11\>_XI2\<11\>\/XI2\<14\>\/RR1_pos \
 N_WLSEL\<381\>_XI2\<11\>\/XI2\<14\>\/RR1_neg ) R_1X_LL w=1e-07 l=1e-07   \
 res=0.149966
XXI2\<11\>\/XI2\<14\>\/RR0 (  N_SEL0\<14\>_XI2\<11\>\/XI2\<14\>\/RR0_pos \
 N_WLSEL\<380\>_XI2\<11\>\/XI2\<14\>\/RR0_neg ) R_1X_LL w=1e-07 l=1e-07   \
 res=0.149966
XXI2\<11\>\/XI2\<13\>\/RR1 (  N_SEL1\<11\>_XI2\<11\>\/XI2\<13\>\/RR1_pos \
 N_WLSEL\<379\>_XI2\<11\>\/XI2\<13\>\/RR1_neg ) R_1X_LL w=1e-07 l=1e-07   \
 res=0.149966
XXI2\<11\>\/XI2\<13\>\/RR0 (  N_SEL0\<13\>_XI2\<11\>\/XI2\<13\>\/RR0_pos \
 N_WLSEL\<378\>_XI2\<11\>\/XI2\<13\>\/RR0_neg ) R_1X_LL w=1e-07 l=1e-07   \
 res=0.149966
XXI2\<11\>\/XI2\<12\>\/RR1 (  N_SEL1\<11\>_XI2\<11\>\/XI2\<12\>\/RR1_pos \
 N_WLSEL\<377\>_XI2\<11\>\/XI2\<12\>\/RR1_neg ) R_1X_LL w=1e-07 l=1e-07   \
 res=0.149966
XXI2\<11\>\/XI2\<12\>\/RR0 (  N_SEL0\<12\>_XI2\<11\>\/XI2\<12\>\/RR0_pos \
 N_WLSEL\<376\>_XI2\<11\>\/XI2\<12\>\/RR0_neg ) R_1X_LL w=1e-07 l=1e-07   \
 res=0.149966
XXI2\<11\>\/XI2\<11\>\/RR1 (  N_SEL1\<11\>_XI2\<11\>\/XI2\<11\>\/RR1_pos \
 N_WLSEL\<375\>_XI2\<11\>\/XI2\<11\>\/RR1_neg ) R_1X_LL w=1e-07 l=1e-07   \
 res=0.149966
XXI2\<11\>\/XI2\<11\>\/RR0 (  N_SEL0\<11\>_XI2\<11\>\/XI2\<11\>\/RR0_pos \
 N_WLSEL\<374\>_XI2\<11\>\/XI2\<11\>\/RR0_neg ) R_1X_LL w=1e-07 l=1e-07   \
 res=0.149966
XXI2\<11\>\/XI2\<10\>\/RR1 (  N_SEL1\<11\>_XI2\<11\>\/XI2\<10\>\/RR1_pos \
 N_WLSEL\<373\>_XI2\<11\>\/XI2\<10\>\/RR1_neg ) R_1X_LL w=1e-07 l=1e-07   \
 res=0.149966
XXI2\<11\>\/XI2\<10\>\/RR0 (  N_SEL0\<10\>_XI2\<11\>\/XI2\<10\>\/RR0_pos \
 N_WLSEL\<372\>_XI2\<11\>\/XI2\<10\>\/RR0_neg ) R_1X_LL w=1e-07 l=1e-07   \
 res=0.149966
XXI2\<11\>\/XI2\<9\>\/RR1 (  N_SEL1\<11\>_XI2\<11\>\/XI2\<9\>\/RR1_pos \
 N_WLSEL\<371\>_XI2\<11\>\/XI2\<9\>\/RR1_neg ) R_1X_LL w=1e-07 l=1e-07   \
 res=0.149966
XXI2\<11\>\/XI2\<9\>\/RR0 (  N_SEL0\<9\>_XI2\<11\>\/XI2\<9\>\/RR0_pos \
 N_WLSEL\<370\>_XI2\<11\>\/XI2\<9\>\/RR0_neg ) R_1X_LL w=1e-07 l=1e-07   \
 res=0.149966
XXI2\<11\>\/XI2\<8\>\/RR1 (  N_SEL1\<11\>_XI2\<11\>\/XI2\<8\>\/RR1_pos \
 N_WLSEL\<369\>_XI2\<11\>\/XI2\<8\>\/RR1_neg ) R_1X_LL w=1e-07 l=1e-07   \
 res=0.149966
XXI2\<11\>\/XI2\<8\>\/RR0 (  N_SEL0\<8\>_XI2\<11\>\/XI2\<8\>\/RR0_pos \
 N_WLSEL\<368\>_XI2\<11\>\/XI2\<8\>\/RR0_neg ) R_1X_LL w=1e-07 l=1e-07   \
 res=0.149966
XXI2\<11\>\/XI2\<7\>\/RR1 (  N_SEL1\<11\>_XI2\<11\>\/XI2\<7\>\/RR1_pos \
 N_WLSEL\<367\>_XI2\<11\>\/XI2\<7\>\/RR1_neg ) R_1X_LL w=1e-07 l=1e-07   \
 res=0.149966
XXI2\<11\>\/XI2\<7\>\/RR0 (  N_SEL0\<7\>_XI2\<11\>\/XI2\<7\>\/RR0_pos \
 N_WLSEL\<366\>_XI2\<11\>\/XI2\<7\>\/RR0_neg ) R_1X_LL w=1e-07 l=1e-07   \
 res=0.149966
XXI2\<11\>\/XI2\<6\>\/RR1 (  N_SEL1\<11\>_XI2\<11\>\/XI2\<6\>\/RR1_pos \
 N_WLSEL\<365\>_XI2\<11\>\/XI2\<6\>\/RR1_neg ) R_1X_LL w=1e-07 l=1e-07   \
 res=0.149966
XXI2\<11\>\/XI2\<6\>\/RR0 (  N_SEL0\<6\>_XI2\<11\>\/XI2\<6\>\/RR0_pos \
 N_WLSEL\<364\>_XI2\<11\>\/XI2\<6\>\/RR0_neg ) R_1X_LL w=1e-07 l=1e-07   \
 res=0.149966
XXI2\<11\>\/XI2\<5\>\/RR1 (  N_SEL1\<11\>_XI2\<11\>\/XI2\<5\>\/RR1_pos \
 N_WLSEL\<363\>_XI2\<11\>\/XI2\<5\>\/RR1_neg ) R_1X_LL w=1e-07 l=1e-07   \
 res=0.149966
XXI2\<11\>\/XI2\<5\>\/RR0 (  N_SEL0\<5\>_XI2\<11\>\/XI2\<5\>\/RR0_pos \
 N_WLSEL\<362\>_XI2\<11\>\/XI2\<5\>\/RR0_neg ) R_1X_LL w=1e-07 l=1e-07   \
 res=0.149966
XXI2\<11\>\/XI2\<4\>\/RR1 (  N_SEL1\<11\>_XI2\<11\>\/XI2\<4\>\/RR1_pos \
 N_WLSEL\<361\>_XI2\<11\>\/XI2\<4\>\/RR1_neg ) R_1X_LL w=1e-07 l=1e-07   \
 res=0.149966
XXI2\<11\>\/XI2\<4\>\/RR0 (  N_SEL0\<4\>_XI2\<11\>\/XI2\<4\>\/RR0_pos \
 N_WLSEL\<360\>_XI2\<11\>\/XI2\<4\>\/RR0_neg ) R_1X_LL w=1e-07 l=1e-07   \
 res=0.149966
XXI2\<11\>\/XI2\<3\>\/RR1 (  N_SEL1\<11\>_XI2\<11\>\/XI2\<3\>\/RR1_pos \
 N_WLSEL\<359\>_XI2\<11\>\/XI2\<3\>\/RR1_neg ) R_1X_LL w=1e-07 l=1e-07   \
 res=0.149966
XXI2\<11\>\/XI2\<3\>\/RR0 (  N_SEL0\<3\>_XI2\<11\>\/XI2\<3\>\/RR0_pos \
 N_WLSEL\<358\>_XI2\<11\>\/XI2\<3\>\/RR0_neg ) R_1X_LL w=1e-07 l=1e-07   \
 res=0.149966
XXI2\<11\>\/XI2\<2\>\/RR1 (  N_SEL1\<11\>_XI2\<11\>\/XI2\<2\>\/RR1_pos \
 N_WLSEL\<357\>_XI2\<11\>\/XI2\<2\>\/RR1_neg ) R_1X_LL w=1e-07 l=1e-07   \
 res=0.149966
XXI2\<11\>\/XI2\<2\>\/RR0 (  N_SEL0\<2\>_XI2\<11\>\/XI2\<2\>\/RR0_pos \
 N_WLSEL\<356\>_XI2\<11\>\/XI2\<2\>\/RR0_neg ) R_1X_LL w=1e-07 l=1e-07   \
 res=0.149966
XXI2\<11\>\/XI2\<1\>\/RR1 (  N_SEL1\<11\>_XI2\<11\>\/XI2\<1\>\/RR1_pos \
 N_WLSEL\<355\>_XI2\<11\>\/XI2\<1\>\/RR1_neg ) R_1X_LL w=1e-07 l=1e-07   \
 res=0.149966
XXI2\<11\>\/XI2\<1\>\/RR0 (  N_SEL0\<1\>_XI2\<11\>\/XI2\<1\>\/RR0_pos \
 N_WLSEL\<354\>_XI2\<11\>\/XI2\<1\>\/RR0_neg ) R_1X_LL w=1e-07 l=1e-07   \
 res=0.149966
XXI2\<11\>\/XI2\<0\>\/RR1 (  N_SEL1\<11\>_XI2\<11\>\/XI2\<0\>\/RR1_pos \
 N_WLSEL\<353\>_XI2\<11\>\/XI2\<0\>\/RR1_neg ) R_1X_LL w=1e-07 l=1e-07   \
 res=0.149966
XXI2\<11\>\/XI2\<0\>\/RR0 (  N_SEL0\<0\>_XI2\<11\>\/XI2\<0\>\/RR0_pos \
 N_WLSEL\<352\>_XI2\<11\>\/XI2\<0\>\/RR0_neg ) R_1X_LL w=1e-07 l=1e-07   \
 res=0.149966
XXI2\<10\>\/XI2\<15\>\/RR1 (  N_SEL1\<10\>_XI2\<10\>\/XI2\<15\>\/RR1_pos \
 N_WLSEL\<351\>_XI2\<10\>\/XI2\<15\>\/RR1_neg ) R_1X_LL w=1e-07 l=1e-07   \
 res=0.149966
XXI2\<10\>\/XI2\<15\>\/RR0 (  N_SEL0\<15\>_XI2\<10\>\/XI2\<15\>\/RR0_pos \
 N_WLSEL\<350\>_XI2\<10\>\/XI2\<15\>\/RR0_neg ) R_1X_LL w=1e-07 l=1e-07   \
 res=0.149966
XXI2\<10\>\/XI2\<14\>\/RR1 (  N_SEL1\<10\>_XI2\<10\>\/XI2\<14\>\/RR1_pos \
 N_WLSEL\<349\>_XI2\<10\>\/XI2\<14\>\/RR1_neg ) R_1X_LL w=1e-07 l=1e-07   \
 res=0.149966
XXI2\<10\>\/XI2\<14\>\/RR0 (  N_SEL0\<14\>_XI2\<10\>\/XI2\<14\>\/RR0_pos \
 N_WLSEL\<348\>_XI2\<10\>\/XI2\<14\>\/RR0_neg ) R_1X_LL w=1e-07 l=1e-07   \
 res=0.149966
XXI2\<10\>\/XI2\<13\>\/RR1 (  N_SEL1\<10\>_XI2\<10\>\/XI2\<13\>\/RR1_pos \
 N_WLSEL\<347\>_XI2\<10\>\/XI2\<13\>\/RR1_neg ) R_1X_LL w=1e-07 l=1e-07   \
 res=0.149966
XXI2\<10\>\/XI2\<13\>\/RR0 (  N_SEL0\<13\>_XI2\<10\>\/XI2\<13\>\/RR0_pos \
 N_WLSEL\<346\>_XI2\<10\>\/XI2\<13\>\/RR0_neg ) R_1X_LL w=1e-07 l=1e-07   \
 res=0.149966
XXI2\<10\>\/XI2\<12\>\/RR1 (  N_SEL1\<10\>_XI2\<10\>\/XI2\<12\>\/RR1_pos \
 N_WLSEL\<345\>_XI2\<10\>\/XI2\<12\>\/RR1_neg ) R_1X_LL w=1e-07 l=1e-07   \
 res=0.149966
XXI2\<10\>\/XI2\<12\>\/RR0 (  N_SEL0\<12\>_XI2\<10\>\/XI2\<12\>\/RR0_pos \
 N_WLSEL\<344\>_XI2\<10\>\/XI2\<12\>\/RR0_neg ) R_1X_LL w=1e-07 l=1e-07   \
 res=0.149966
XXI2\<10\>\/XI2\<11\>\/RR1 (  N_SEL1\<10\>_XI2\<10\>\/XI2\<11\>\/RR1_pos \
 N_WLSEL\<343\>_XI2\<10\>\/XI2\<11\>\/RR1_neg ) R_1X_LL w=1e-07 l=1e-07   \
 res=0.149966
XXI2\<10\>\/XI2\<11\>\/RR0 (  N_SEL0\<11\>_XI2\<10\>\/XI2\<11\>\/RR0_pos \
 N_WLSEL\<342\>_XI2\<10\>\/XI2\<11\>\/RR0_neg ) R_1X_LL w=1e-07 l=1e-07   \
 res=0.149966
XXI2\<10\>\/XI2\<10\>\/RR1 (  N_SEL1\<10\>_XI2\<10\>\/XI2\<10\>\/RR1_pos \
 N_WLSEL\<341\>_XI2\<10\>\/XI2\<10\>\/RR1_neg ) R_1X_LL w=1e-07 l=1e-07   \
 res=0.149966
XXI2\<10\>\/XI2\<10\>\/RR0 (  N_SEL0\<10\>_XI2\<10\>\/XI2\<10\>\/RR0_pos \
 N_WLSEL\<340\>_XI2\<10\>\/XI2\<10\>\/RR0_neg ) R_1X_LL w=1e-07 l=1e-07   \
 res=0.149966
XXI2\<10\>\/XI2\<9\>\/RR1 (  N_SEL1\<10\>_XI2\<10\>\/XI2\<9\>\/RR1_pos \
 N_WLSEL\<339\>_XI2\<10\>\/XI2\<9\>\/RR1_neg ) R_1X_LL w=1e-07 l=1e-07   \
 res=0.149966
XXI2\<10\>\/XI2\<9\>\/RR0 (  N_SEL0\<9\>_XI2\<10\>\/XI2\<9\>\/RR0_pos \
 N_WLSEL\<338\>_XI2\<10\>\/XI2\<9\>\/RR0_neg ) R_1X_LL w=1e-07 l=1e-07   \
 res=0.149966
XXI2\<10\>\/XI2\<8\>\/RR1 (  N_SEL1\<10\>_XI2\<10\>\/XI2\<8\>\/RR1_pos \
 N_WLSEL\<337\>_XI2\<10\>\/XI2\<8\>\/RR1_neg ) R_1X_LL w=1e-07 l=1e-07   \
 res=0.149966
XXI2\<10\>\/XI2\<8\>\/RR0 (  N_SEL0\<8\>_XI2\<10\>\/XI2\<8\>\/RR0_pos \
 N_WLSEL\<336\>_XI2\<10\>\/XI2\<8\>\/RR0_neg ) R_1X_LL w=1e-07 l=1e-07   \
 res=0.149966
XXI2\<10\>\/XI2\<7\>\/RR1 (  N_SEL1\<10\>_XI2\<10\>\/XI2\<7\>\/RR1_pos \
 N_WLSEL\<335\>_XI2\<10\>\/XI2\<7\>\/RR1_neg ) R_1X_LL w=1e-07 l=1e-07   \
 res=0.149966
XXI2\<10\>\/XI2\<7\>\/RR0 (  N_SEL0\<7\>_XI2\<10\>\/XI2\<7\>\/RR0_pos \
 N_WLSEL\<334\>_XI2\<10\>\/XI2\<7\>\/RR0_neg ) R_1X_LL w=1e-07 l=1e-07   \
 res=0.149966
XXI2\<10\>\/XI2\<6\>\/RR1 (  N_SEL1\<10\>_XI2\<10\>\/XI2\<6\>\/RR1_pos \
 N_WLSEL\<333\>_XI2\<10\>\/XI2\<6\>\/RR1_neg ) R_1X_LL w=1e-07 l=1e-07   \
 res=0.149966
XXI2\<10\>\/XI2\<6\>\/RR0 (  N_SEL0\<6\>_XI2\<10\>\/XI2\<6\>\/RR0_pos \
 N_WLSEL\<332\>_XI2\<10\>\/XI2\<6\>\/RR0_neg ) R_1X_LL w=1e-07 l=1e-07   \
 res=0.149966
XXI2\<10\>\/XI2\<5\>\/RR1 (  N_SEL1\<10\>_XI2\<10\>\/XI2\<5\>\/RR1_pos \
 N_WLSEL\<331\>_XI2\<10\>\/XI2\<5\>\/RR1_neg ) R_1X_LL w=1e-07 l=1e-07   \
 res=0.149966
XXI2\<10\>\/XI2\<5\>\/RR0 (  N_SEL0\<5\>_XI2\<10\>\/XI2\<5\>\/RR0_pos \
 N_WLSEL\<330\>_XI2\<10\>\/XI2\<5\>\/RR0_neg ) R_1X_LL w=1e-07 l=1e-07   \
 res=0.149966
XXI2\<10\>\/XI2\<4\>\/RR1 (  N_SEL1\<10\>_XI2\<10\>\/XI2\<4\>\/RR1_pos \
 N_WLSEL\<329\>_XI2\<10\>\/XI2\<4\>\/RR1_neg ) R_1X_LL w=1e-07 l=1e-07   \
 res=0.149966
XXI2\<10\>\/XI2\<4\>\/RR0 (  N_SEL0\<4\>_XI2\<10\>\/XI2\<4\>\/RR0_pos \
 N_WLSEL\<328\>_XI2\<10\>\/XI2\<4\>\/RR0_neg ) R_1X_LL w=1e-07 l=1e-07   \
 res=0.149966
XXI2\<10\>\/XI2\<3\>\/RR1 (  N_SEL1\<10\>_XI2\<10\>\/XI2\<3\>\/RR1_pos \
 N_WLSEL\<327\>_XI2\<10\>\/XI2\<3\>\/RR1_neg ) R_1X_LL w=1e-07 l=1e-07   \
 res=0.149966
XXI2\<10\>\/XI2\<3\>\/RR0 (  N_SEL0\<3\>_XI2\<10\>\/XI2\<3\>\/RR0_pos \
 N_WLSEL\<326\>_XI2\<10\>\/XI2\<3\>\/RR0_neg ) R_1X_LL w=1e-07 l=1e-07   \
 res=0.149966
XXI2\<10\>\/XI2\<2\>\/RR1 (  N_SEL1\<10\>_XI2\<10\>\/XI2\<2\>\/RR1_pos \
 N_WLSEL\<325\>_XI2\<10\>\/XI2\<2\>\/RR1_neg ) R_1X_LL w=1e-07 l=1e-07   \
 res=0.149966
XXI2\<10\>\/XI2\<2\>\/RR0 (  N_SEL0\<2\>_XI2\<10\>\/XI2\<2\>\/RR0_pos \
 N_WLSEL\<324\>_XI2\<10\>\/XI2\<2\>\/RR0_neg ) R_1X_LL w=1e-07 l=1e-07   \
 res=0.149966
XXI2\<10\>\/XI2\<1\>\/RR1 (  N_SEL1\<10\>_XI2\<10\>\/XI2\<1\>\/RR1_pos \
 N_WLSEL\<323\>_XI2\<10\>\/XI2\<1\>\/RR1_neg ) R_1X_LL w=1e-07 l=1e-07   \
 res=0.149966
XXI2\<10\>\/XI2\<1\>\/RR0 (  N_SEL0\<1\>_XI2\<10\>\/XI2\<1\>\/RR0_pos \
 N_WLSEL\<322\>_XI2\<10\>\/XI2\<1\>\/RR0_neg ) R_1X_LL w=1e-07 l=1e-07   \
 res=0.149966
XXI2\<10\>\/XI2\<0\>\/RR1 (  N_SEL1\<10\>_XI2\<10\>\/XI2\<0\>\/RR1_pos \
 N_WLSEL\<321\>_XI2\<10\>\/XI2\<0\>\/RR1_neg ) R_1X_LL w=1e-07 l=1e-07   \
 res=0.149966
XXI2\<10\>\/XI2\<0\>\/RR0 (  N_SEL0\<0\>_XI2\<10\>\/XI2\<0\>\/RR0_pos \
 N_WLSEL\<320\>_XI2\<10\>\/XI2\<0\>\/RR0_neg ) R_1X_LL w=1e-07 l=1e-07   \
 res=0.149966
XXI2\<9\>\/XI2\<15\>\/RR1 (  N_SEL1\<9\>_XI2\<9\>\/XI2\<15\>\/RR1_pos \
 N_WLSEL\<319\>_XI2\<9\>\/XI2\<15\>\/RR1_neg ) R_1X_LL w=1e-07 l=1e-07   \
 res=0.149966
XXI2\<9\>\/XI2\<15\>\/RR0 (  N_SEL0\<15\>_XI2\<9\>\/XI2\<15\>\/RR0_pos \
 N_WLSEL\<318\>_XI2\<9\>\/XI2\<15\>\/RR0_neg ) R_1X_LL w=1e-07 l=1e-07   \
 res=0.149966
XXI2\<9\>\/XI2\<14\>\/RR1 (  N_SEL1\<9\>_XI2\<9\>\/XI2\<14\>\/RR1_pos \
 N_WLSEL\<317\>_XI2\<9\>\/XI2\<14\>\/RR1_neg ) R_1X_LL w=1e-07 l=1e-07   \
 res=0.149966
XXI2\<9\>\/XI2\<14\>\/RR0 (  N_SEL0\<14\>_XI2\<9\>\/XI2\<14\>\/RR0_pos \
 N_WLSEL\<316\>_XI2\<9\>\/XI2\<14\>\/RR0_neg ) R_1X_LL w=1e-07 l=1e-07   \
 res=0.149966
XXI2\<9\>\/XI2\<13\>\/RR1 (  N_SEL1\<9\>_XI2\<9\>\/XI2\<13\>\/RR1_pos \
 N_WLSEL\<315\>_XI2\<9\>\/XI2\<13\>\/RR1_neg ) R_1X_LL w=1e-07 l=1e-07   \
 res=0.149966
XXI2\<9\>\/XI2\<13\>\/RR0 (  N_SEL0\<13\>_XI2\<9\>\/XI2\<13\>\/RR0_pos \
 N_WLSEL\<314\>_XI2\<9\>\/XI2\<13\>\/RR0_neg ) R_1X_LL w=1e-07 l=1e-07   \
 res=0.149966
XXI2\<9\>\/XI2\<12\>\/RR1 (  N_SEL1\<9\>_XI2\<9\>\/XI2\<12\>\/RR1_pos \
 N_WLSEL\<313\>_XI2\<9\>\/XI2\<12\>\/RR1_neg ) R_1X_LL w=1e-07 l=1e-07   \
 res=0.149966
XXI2\<9\>\/XI2\<12\>\/RR0 (  N_SEL0\<12\>_XI2\<9\>\/XI2\<12\>\/RR0_pos \
 N_WLSEL\<312\>_XI2\<9\>\/XI2\<12\>\/RR0_neg ) R_1X_LL w=1e-07 l=1e-07   \
 res=0.149966
XXI2\<9\>\/XI2\<11\>\/RR1 (  N_SEL1\<9\>_XI2\<9\>\/XI2\<11\>\/RR1_pos \
 N_WLSEL\<311\>_XI2\<9\>\/XI2\<11\>\/RR1_neg ) R_1X_LL w=1e-07 l=1e-07   \
 res=0.149966
XXI2\<9\>\/XI2\<11\>\/RR0 (  N_SEL0\<11\>_XI2\<9\>\/XI2\<11\>\/RR0_pos \
 N_WLSEL\<310\>_XI2\<9\>\/XI2\<11\>\/RR0_neg ) R_1X_LL w=1e-07 l=1e-07   \
 res=0.149966
XXI2\<9\>\/XI2\<10\>\/RR1 (  N_SEL1\<9\>_XI2\<9\>\/XI2\<10\>\/RR1_pos \
 N_WLSEL\<309\>_XI2\<9\>\/XI2\<10\>\/RR1_neg ) R_1X_LL w=1e-07 l=1e-07   \
 res=0.149966
XXI2\<9\>\/XI2\<10\>\/RR0 (  N_SEL0\<10\>_XI2\<9\>\/XI2\<10\>\/RR0_pos \
 N_WLSEL\<308\>_XI2\<9\>\/XI2\<10\>\/RR0_neg ) R_1X_LL w=1e-07 l=1e-07   \
 res=0.149966
XXI2\<9\>\/XI2\<9\>\/RR1 (  N_SEL1\<9\>_XI2\<9\>\/XI2\<9\>\/RR1_pos \
 N_WLSEL\<307\>_XI2\<9\>\/XI2\<9\>\/RR1_neg ) R_1X_LL w=1e-07 l=1e-07   \
 res=0.149966
XXI2\<9\>\/XI2\<9\>\/RR0 (  N_SEL0\<9\>_XI2\<9\>\/XI2\<9\>\/RR0_pos \
 N_WLSEL\<306\>_XI2\<9\>\/XI2\<9\>\/RR0_neg ) R_1X_LL w=1e-07 l=1e-07   \
 res=0.149966
XXI2\<9\>\/XI2\<8\>\/RR1 (  N_SEL1\<9\>_XI2\<9\>\/XI2\<8\>\/RR1_pos \
 N_WLSEL\<305\>_XI2\<9\>\/XI2\<8\>\/RR1_neg ) R_1X_LL w=1e-07 l=1e-07   \
 res=0.149966
XXI2\<9\>\/XI2\<8\>\/RR0 (  N_SEL0\<8\>_XI2\<9\>\/XI2\<8\>\/RR0_pos \
 N_WLSEL\<304\>_XI2\<9\>\/XI2\<8\>\/RR0_neg ) R_1X_LL w=1e-07 l=1e-07   \
 res=0.149966
XXI2\<9\>\/XI2\<7\>\/RR1 (  N_SEL1\<9\>_XI2\<9\>\/XI2\<7\>\/RR1_pos \
 N_WLSEL\<303\>_XI2\<9\>\/XI2\<7\>\/RR1_neg ) R_1X_LL w=1e-07 l=1e-07   \
 res=0.149966
XXI2\<9\>\/XI2\<7\>\/RR0 (  N_SEL0\<7\>_XI2\<9\>\/XI2\<7\>\/RR0_pos \
 N_WLSEL\<302\>_XI2\<9\>\/XI2\<7\>\/RR0_neg ) R_1X_LL w=1e-07 l=1e-07   \
 res=0.149966
XXI2\<9\>\/XI2\<6\>\/RR1 (  N_SEL1\<9\>_XI2\<9\>\/XI2\<6\>\/RR1_pos \
 N_WLSEL\<301\>_XI2\<9\>\/XI2\<6\>\/RR1_neg ) R_1X_LL w=1e-07 l=1e-07   \
 res=0.149966
XXI2\<9\>\/XI2\<6\>\/RR0 (  N_SEL0\<6\>_XI2\<9\>\/XI2\<6\>\/RR0_pos \
 N_WLSEL\<300\>_XI2\<9\>\/XI2\<6\>\/RR0_neg ) R_1X_LL w=1e-07 l=1e-07   \
 res=0.149966
XXI2\<9\>\/XI2\<5\>\/RR1 (  N_SEL1\<9\>_XI2\<9\>\/XI2\<5\>\/RR1_pos \
 N_WLSEL\<299\>_XI2\<9\>\/XI2\<5\>\/RR1_neg ) R_1X_LL w=1e-07 l=1e-07   \
 res=0.149966
XXI2\<9\>\/XI2\<5\>\/RR0 (  N_SEL0\<5\>_XI2\<9\>\/XI2\<5\>\/RR0_pos \
 N_WLSEL\<298\>_XI2\<9\>\/XI2\<5\>\/RR0_neg ) R_1X_LL w=1e-07 l=1e-07   \
 res=0.149966
XXI2\<9\>\/XI2\<4\>\/RR1 (  N_SEL1\<9\>_XI2\<9\>\/XI2\<4\>\/RR1_pos \
 N_WLSEL\<297\>_XI2\<9\>\/XI2\<4\>\/RR1_neg ) R_1X_LL w=1e-07 l=1e-07   \
 res=0.149966
XXI2\<9\>\/XI2\<4\>\/RR0 (  N_SEL0\<4\>_XI2\<9\>\/XI2\<4\>\/RR0_pos \
 N_WLSEL\<296\>_XI2\<9\>\/XI2\<4\>\/RR0_neg ) R_1X_LL w=1e-07 l=1e-07   \
 res=0.149966
XXI2\<9\>\/XI2\<3\>\/RR1 (  N_SEL1\<9\>_XI2\<9\>\/XI2\<3\>\/RR1_pos \
 N_WLSEL\<295\>_XI2\<9\>\/XI2\<3\>\/RR1_neg ) R_1X_LL w=1e-07 l=1e-07   \
 res=0.149966
XXI2\<9\>\/XI2\<3\>\/RR0 (  N_SEL0\<3\>_XI2\<9\>\/XI2\<3\>\/RR0_pos \
 N_WLSEL\<294\>_XI2\<9\>\/XI2\<3\>\/RR0_neg ) R_1X_LL w=1e-07 l=1e-07   \
 res=0.149966
XXI2\<9\>\/XI2\<2\>\/RR1 (  N_SEL1\<9\>_XI2\<9\>\/XI2\<2\>\/RR1_pos \
 N_WLSEL\<293\>_XI2\<9\>\/XI2\<2\>\/RR1_neg ) R_1X_LL w=1e-07 l=1e-07   \
 res=0.149966
XXI2\<9\>\/XI2\<2\>\/RR0 (  N_SEL0\<2\>_XI2\<9\>\/XI2\<2\>\/RR0_pos \
 N_WLSEL\<292\>_XI2\<9\>\/XI2\<2\>\/RR0_neg ) R_1X_LL w=1e-07 l=1e-07   \
 res=0.149966
XXI2\<9\>\/XI2\<1\>\/RR1 (  N_SEL1\<9\>_XI2\<9\>\/XI2\<1\>\/RR1_pos \
 N_WLSEL\<291\>_XI2\<9\>\/XI2\<1\>\/RR1_neg ) R_1X_LL w=1e-07 l=1e-07   \
 res=0.149966
XXI2\<9\>\/XI2\<1\>\/RR0 (  N_SEL0\<1\>_XI2\<9\>\/XI2\<1\>\/RR0_pos \
 N_WLSEL\<290\>_XI2\<9\>\/XI2\<1\>\/RR0_neg ) R_1X_LL w=1e-07 l=1e-07   \
 res=0.149966
XXI2\<9\>\/XI2\<0\>\/RR1 (  N_SEL1\<9\>_XI2\<9\>\/XI2\<0\>\/RR1_pos \
 N_WLSEL\<289\>_XI2\<9\>\/XI2\<0\>\/RR1_neg ) R_1X_LL w=1e-07 l=1e-07   \
 res=0.149966
XXI2\<9\>\/XI2\<0\>\/RR0 (  N_SEL0\<0\>_XI2\<9\>\/XI2\<0\>\/RR0_pos \
 N_WLSEL\<288\>_XI2\<9\>\/XI2\<0\>\/RR0_neg ) R_1X_LL w=1e-07 l=1e-07   \
 res=0.149966
XXI2\<8\>\/XI2\<15\>\/RR1 (  N_SEL1\<8\>_XI2\<8\>\/XI2\<15\>\/RR1_pos \
 N_WLSEL\<287\>_XI2\<8\>\/XI2\<15\>\/RR1_neg ) R_1X_LL w=1e-07 l=1e-07   \
 res=0.149966
XXI2\<8\>\/XI2\<15\>\/RR0 (  N_SEL0\<15\>_XI2\<8\>\/XI2\<15\>\/RR0_pos \
 N_WLSEL\<286\>_XI2\<8\>\/XI2\<15\>\/RR0_neg ) R_1X_LL w=1e-07 l=1e-07   \
 res=0.149966
XXI2\<8\>\/XI2\<14\>\/RR1 (  N_SEL1\<8\>_XI2\<8\>\/XI2\<14\>\/RR1_pos \
 N_WLSEL\<285\>_XI2\<8\>\/XI2\<14\>\/RR1_neg ) R_1X_LL w=1e-07 l=1e-07   \
 res=0.149966
XXI2\<8\>\/XI2\<14\>\/RR0 (  N_SEL0\<14\>_XI2\<8\>\/XI2\<14\>\/RR0_pos \
 N_WLSEL\<284\>_XI2\<8\>\/XI2\<14\>\/RR0_neg ) R_1X_LL w=1e-07 l=1e-07   \
 res=0.149966
XXI2\<8\>\/XI2\<13\>\/RR1 (  N_SEL1\<8\>_XI2\<8\>\/XI2\<13\>\/RR1_pos \
 N_WLSEL\<283\>_XI2\<8\>\/XI2\<13\>\/RR1_neg ) R_1X_LL w=1e-07 l=1e-07   \
 res=0.149966
XXI2\<8\>\/XI2\<13\>\/RR0 (  N_SEL0\<13\>_XI2\<8\>\/XI2\<13\>\/RR0_pos \
 N_WLSEL\<282\>_XI2\<8\>\/XI2\<13\>\/RR0_neg ) R_1X_LL w=1e-07 l=1e-07   \
 res=0.149966
XXI2\<8\>\/XI2\<12\>\/RR1 (  N_SEL1\<8\>_XI2\<8\>\/XI2\<12\>\/RR1_pos \
 N_WLSEL\<281\>_XI2\<8\>\/XI2\<12\>\/RR1_neg ) R_1X_LL w=1e-07 l=1e-07   \
 res=0.149966
XXI2\<8\>\/XI2\<12\>\/RR0 (  N_SEL0\<12\>_XI2\<8\>\/XI2\<12\>\/RR0_pos \
 N_WLSEL\<280\>_XI2\<8\>\/XI2\<12\>\/RR0_neg ) R_1X_LL w=1e-07 l=1e-07   \
 res=0.149966
XXI2\<8\>\/XI2\<11\>\/RR1 (  N_SEL1\<8\>_XI2\<8\>\/XI2\<11\>\/RR1_pos \
 N_WLSEL\<279\>_XI2\<8\>\/XI2\<11\>\/RR1_neg ) R_1X_LL w=1e-07 l=1e-07   \
 res=0.149966
XXI2\<8\>\/XI2\<11\>\/RR0 (  N_SEL0\<11\>_XI2\<8\>\/XI2\<11\>\/RR0_pos \
 N_WLSEL\<278\>_XI2\<8\>\/XI2\<11\>\/RR0_neg ) R_1X_LL w=1e-07 l=1e-07   \
 res=0.149966
XXI2\<8\>\/XI2\<10\>\/RR1 (  N_SEL1\<8\>_XI2\<8\>\/XI2\<10\>\/RR1_pos \
 N_WLSEL\<277\>_XI2\<8\>\/XI2\<10\>\/RR1_neg ) R_1X_LL w=1e-07 l=1e-07   \
 res=0.149966
XXI2\<8\>\/XI2\<10\>\/RR0 (  N_SEL0\<10\>_XI2\<8\>\/XI2\<10\>\/RR0_pos \
 N_WLSEL\<276\>_XI2\<8\>\/XI2\<10\>\/RR0_neg ) R_1X_LL w=1e-07 l=1e-07   \
 res=0.149966
XXI2\<8\>\/XI2\<9\>\/RR1 (  N_SEL1\<8\>_XI2\<8\>\/XI2\<9\>\/RR1_pos \
 N_WLSEL\<275\>_XI2\<8\>\/XI2\<9\>\/RR1_neg ) R_1X_LL w=1e-07 l=1e-07   \
 res=0.149966
XXI2\<8\>\/XI2\<9\>\/RR0 (  N_SEL0\<9\>_XI2\<8\>\/XI2\<9\>\/RR0_pos \
 N_WLSEL\<274\>_XI2\<8\>\/XI2\<9\>\/RR0_neg ) R_1X_LL w=1e-07 l=1e-07   \
 res=0.149966
XXI2\<8\>\/XI2\<8\>\/RR1 (  N_SEL1\<8\>_XI2\<8\>\/XI2\<8\>\/RR1_pos \
 N_WLSEL\<273\>_XI2\<8\>\/XI2\<8\>\/RR1_neg ) R_1X_LL w=1e-07 l=1e-07   \
 res=0.149966
XXI2\<8\>\/XI2\<8\>\/RR0 (  N_SEL0\<8\>_XI2\<8\>\/XI2\<8\>\/RR0_pos \
 N_WLSEL\<272\>_XI2\<8\>\/XI2\<8\>\/RR0_neg ) R_1X_LL w=1e-07 l=1e-07   \
 res=0.149966
XXI2\<8\>\/XI2\<7\>\/RR1 (  N_SEL1\<8\>_XI2\<8\>\/XI2\<7\>\/RR1_pos \
 N_WLSEL\<271\>_XI2\<8\>\/XI2\<7\>\/RR1_neg ) R_1X_LL w=1e-07 l=1e-07   \
 res=0.149966
XXI2\<8\>\/XI2\<7\>\/RR0 (  N_SEL0\<7\>_XI2\<8\>\/XI2\<7\>\/RR0_pos \
 N_WLSEL\<270\>_XI2\<8\>\/XI2\<7\>\/RR0_neg ) R_1X_LL w=1e-07 l=1e-07   \
 res=0.149966
XXI2\<8\>\/XI2\<6\>\/RR1 (  N_SEL1\<8\>_XI2\<8\>\/XI2\<6\>\/RR1_pos \
 N_WLSEL\<269\>_XI2\<8\>\/XI2\<6\>\/RR1_neg ) R_1X_LL w=1e-07 l=1e-07   \
 res=0.149966
XXI2\<8\>\/XI2\<6\>\/RR0 (  N_SEL0\<6\>_XI2\<8\>\/XI2\<6\>\/RR0_pos \
 N_WLSEL\<268\>_XI2\<8\>\/XI2\<6\>\/RR0_neg ) R_1X_LL w=1e-07 l=1e-07   \
 res=0.149966
XXI2\<8\>\/XI2\<5\>\/RR1 (  N_SEL1\<8\>_XI2\<8\>\/XI2\<5\>\/RR1_pos \
 N_WLSEL\<267\>_XI2\<8\>\/XI2\<5\>\/RR1_neg ) R_1X_LL w=1e-07 l=1e-07   \
 res=0.149966
XXI2\<8\>\/XI2\<5\>\/RR0 (  N_SEL0\<5\>_XI2\<8\>\/XI2\<5\>\/RR0_pos \
 N_WLSEL\<266\>_XI2\<8\>\/XI2\<5\>\/RR0_neg ) R_1X_LL w=1e-07 l=1e-07   \
 res=0.149966
XXI2\<8\>\/XI2\<4\>\/RR1 (  N_SEL1\<8\>_XI2\<8\>\/XI2\<4\>\/RR1_pos \
 N_WLSEL\<265\>_XI2\<8\>\/XI2\<4\>\/RR1_neg ) R_1X_LL w=1e-07 l=1e-07   \
 res=0.149966
XXI2\<8\>\/XI2\<4\>\/RR0 (  N_SEL0\<4\>_XI2\<8\>\/XI2\<4\>\/RR0_pos \
 N_WLSEL\<264\>_XI2\<8\>\/XI2\<4\>\/RR0_neg ) R_1X_LL w=1e-07 l=1e-07   \
 res=0.149966
XXI2\<8\>\/XI2\<3\>\/RR1 (  N_SEL1\<8\>_XI2\<8\>\/XI2\<3\>\/RR1_pos \
 N_WLSEL\<263\>_XI2\<8\>\/XI2\<3\>\/RR1_neg ) R_1X_LL w=1e-07 l=1e-07   \
 res=0.149966
XXI2\<8\>\/XI2\<3\>\/RR0 (  N_SEL0\<3\>_XI2\<8\>\/XI2\<3\>\/RR0_pos \
 N_WLSEL\<262\>_XI2\<8\>\/XI2\<3\>\/RR0_neg ) R_1X_LL w=1e-07 l=1e-07   \
 res=0.149966
XXI2\<8\>\/XI2\<2\>\/RR1 (  N_SEL1\<8\>_XI2\<8\>\/XI2\<2\>\/RR1_pos \
 N_WLSEL\<261\>_XI2\<8\>\/XI2\<2\>\/RR1_neg ) R_1X_LL w=1e-07 l=1e-07   \
 res=0.149966
XXI2\<8\>\/XI2\<2\>\/RR0 (  N_SEL0\<2\>_XI2\<8\>\/XI2\<2\>\/RR0_pos \
 N_WLSEL\<260\>_XI2\<8\>\/XI2\<2\>\/RR0_neg ) R_1X_LL w=1e-07 l=1e-07   \
 res=0.149966
XXI2\<8\>\/XI2\<1\>\/RR1 (  N_SEL1\<8\>_XI2\<8\>\/XI2\<1\>\/RR1_pos \
 N_WLSEL\<259\>_XI2\<8\>\/XI2\<1\>\/RR1_neg ) R_1X_LL w=1e-07 l=1e-07   \
 res=0.149966
XXI2\<8\>\/XI2\<1\>\/RR0 (  N_SEL0\<1\>_XI2\<8\>\/XI2\<1\>\/RR0_pos \
 N_WLSEL\<258\>_XI2\<8\>\/XI2\<1\>\/RR0_neg ) R_1X_LL w=1e-07 l=1e-07   \
 res=0.149966
XXI2\<8\>\/XI2\<0\>\/RR1 (  N_SEL1\<8\>_XI2\<8\>\/XI2\<0\>\/RR1_pos \
 N_WLSEL\<257\>_XI2\<8\>\/XI2\<0\>\/RR1_neg ) R_1X_LL w=1e-07 l=1e-07   \
 res=0.149966
XXI2\<8\>\/XI2\<0\>\/RR0 (  N_SEL0\<0\>_XI2\<8\>\/XI2\<0\>\/RR0_pos \
 N_WLSEL\<256\>_XI2\<8\>\/XI2\<0\>\/RR0_neg ) R_1X_LL w=1e-07 l=1e-07   \
 res=0.149966
XXI2\<7\>\/XI2\<15\>\/RR1 (  N_SEL1\<7\>_XI2\<7\>\/XI2\<15\>\/RR1_pos \
 N_WLSEL\<255\>_XI2\<7\>\/XI2\<15\>\/RR1_neg ) R_1X_LL w=1e-07 l=1e-07   \
 res=0.149966
XXI2\<7\>\/XI2\<15\>\/RR0 (  N_SEL0\<15\>_XI2\<7\>\/XI2\<15\>\/RR0_pos \
 N_WLSEL\<254\>_XI2\<7\>\/XI2\<15\>\/RR0_neg ) R_1X_LL w=1e-07 l=1e-07   \
 res=0.149966
XXI2\<7\>\/XI2\<14\>\/RR1 (  N_SEL1\<7\>_XI2\<7\>\/XI2\<14\>\/RR1_pos \
 N_WLSEL\<253\>_XI2\<7\>\/XI2\<14\>\/RR1_neg ) R_1X_LL w=1e-07 l=1e-07   \
 res=0.149966
XXI2\<7\>\/XI2\<14\>\/RR0 (  N_SEL0\<14\>_XI2\<7\>\/XI2\<14\>\/RR0_pos \
 N_WLSEL\<252\>_XI2\<7\>\/XI2\<14\>\/RR0_neg ) R_1X_LL w=1e-07 l=1e-07   \
 res=0.149966
XXI2\<7\>\/XI2\<13\>\/RR1 (  N_SEL1\<7\>_XI2\<7\>\/XI2\<13\>\/RR1_pos \
 N_WLSEL\<251\>_XI2\<7\>\/XI2\<13\>\/RR1_neg ) R_1X_LL w=1e-07 l=1e-07   \
 res=0.149966
XXI2\<7\>\/XI2\<13\>\/RR0 (  N_SEL0\<13\>_XI2\<7\>\/XI2\<13\>\/RR0_pos \
 N_WLSEL\<250\>_XI2\<7\>\/XI2\<13\>\/RR0_neg ) R_1X_LL w=1e-07 l=1e-07   \
 res=0.149966
XXI2\<7\>\/XI2\<12\>\/RR1 (  N_SEL1\<7\>_XI2\<7\>\/XI2\<12\>\/RR1_pos \
 N_WLSEL\<249\>_XI2\<7\>\/XI2\<12\>\/RR1_neg ) R_1X_LL w=1e-07 l=1e-07   \
 res=0.149966
XXI2\<7\>\/XI2\<12\>\/RR0 (  N_SEL0\<12\>_XI2\<7\>\/XI2\<12\>\/RR0_pos \
 N_WLSEL\<248\>_XI2\<7\>\/XI2\<12\>\/RR0_neg ) R_1X_LL w=1e-07 l=1e-07   \
 res=0.149966
XXI2\<7\>\/XI2\<11\>\/RR1 (  N_SEL1\<7\>_XI2\<7\>\/XI2\<11\>\/RR1_pos \
 N_WLSEL\<247\>_XI2\<7\>\/XI2\<11\>\/RR1_neg ) R_1X_LL w=1e-07 l=1e-07   \
 res=0.149966
XXI2\<7\>\/XI2\<11\>\/RR0 (  N_SEL0\<11\>_XI2\<7\>\/XI2\<11\>\/RR0_pos \
 N_WLSEL\<246\>_XI2\<7\>\/XI2\<11\>\/RR0_neg ) R_1X_LL w=1e-07 l=1e-07   \
 res=0.149966
XXI2\<7\>\/XI2\<10\>\/RR1 (  N_SEL1\<7\>_XI2\<7\>\/XI2\<10\>\/RR1_pos \
 N_WLSEL\<245\>_XI2\<7\>\/XI2\<10\>\/RR1_neg ) R_1X_LL w=1e-07 l=1e-07   \
 res=0.149966
XXI2\<7\>\/XI2\<10\>\/RR0 (  N_SEL0\<10\>_XI2\<7\>\/XI2\<10\>\/RR0_pos \
 N_WLSEL\<244\>_XI2\<7\>\/XI2\<10\>\/RR0_neg ) R_1X_LL w=1e-07 l=1e-07   \
 res=0.149966
XXI2\<7\>\/XI2\<9\>\/RR1 (  N_SEL1\<7\>_XI2\<7\>\/XI2\<9\>\/RR1_pos \
 N_WLSEL\<243\>_XI2\<7\>\/XI2\<9\>\/RR1_neg ) R_1X_LL w=1e-07 l=1e-07   \
 res=0.149966
XXI2\<7\>\/XI2\<9\>\/RR0 (  N_SEL0\<9\>_XI2\<7\>\/XI2\<9\>\/RR0_pos \
 N_WLSEL\<242\>_XI2\<7\>\/XI2\<9\>\/RR0_neg ) R_1X_LL w=1e-07 l=1e-07   \
 res=0.149966
XXI2\<7\>\/XI2\<8\>\/RR1 (  N_SEL1\<7\>_XI2\<7\>\/XI2\<8\>\/RR1_pos \
 N_WLSEL\<241\>_XI2\<7\>\/XI2\<8\>\/RR1_neg ) R_1X_LL w=1e-07 l=1e-07   \
 res=0.149966
XXI2\<7\>\/XI2\<8\>\/RR0 (  N_SEL0\<8\>_XI2\<7\>\/XI2\<8\>\/RR0_pos \
 N_WLSEL\<240\>_XI2\<7\>\/XI2\<8\>\/RR0_neg ) R_1X_LL w=1e-07 l=1e-07   \
 res=0.149966
XXI2\<7\>\/XI2\<7\>\/RR1 (  N_SEL1\<7\>_XI2\<7\>\/XI2\<7\>\/RR1_pos \
 N_WLSEL\<239\>_XI2\<7\>\/XI2\<7\>\/RR1_neg ) R_1X_LL w=1e-07 l=1e-07   \
 res=0.149966
XXI2\<7\>\/XI2\<7\>\/RR0 (  N_SEL0\<7\>_XI2\<7\>\/XI2\<7\>\/RR0_pos \
 N_WLSEL\<238\>_XI2\<7\>\/XI2\<7\>\/RR0_neg ) R_1X_LL w=1e-07 l=1e-07   \
 res=0.149966
XXI2\<7\>\/XI2\<6\>\/RR1 (  N_SEL1\<7\>_XI2\<7\>\/XI2\<6\>\/RR1_pos \
 N_WLSEL\<237\>_XI2\<7\>\/XI2\<6\>\/RR1_neg ) R_1X_LL w=1e-07 l=1e-07   \
 res=0.149966
XXI2\<7\>\/XI2\<6\>\/RR0 (  N_SEL0\<6\>_XI2\<7\>\/XI2\<6\>\/RR0_pos \
 N_WLSEL\<236\>_XI2\<7\>\/XI2\<6\>\/RR0_neg ) R_1X_LL w=1e-07 l=1e-07   \
 res=0.149966
XXI2\<7\>\/XI2\<5\>\/RR1 (  N_SEL1\<7\>_XI2\<7\>\/XI2\<5\>\/RR1_pos \
 N_WLSEL\<235\>_XI2\<7\>\/XI2\<5\>\/RR1_neg ) R_1X_LL w=1e-07 l=1e-07   \
 res=0.149966
XXI2\<7\>\/XI2\<5\>\/RR0 (  N_SEL0\<5\>_XI2\<7\>\/XI2\<5\>\/RR0_pos \
 N_WLSEL\<234\>_XI2\<7\>\/XI2\<5\>\/RR0_neg ) R_1X_LL w=1e-07 l=1e-07   \
 res=0.149966
XXI2\<7\>\/XI2\<4\>\/RR1 (  N_SEL1\<7\>_XI2\<7\>\/XI2\<4\>\/RR1_pos \
 N_WLSEL\<233\>_XI2\<7\>\/XI2\<4\>\/RR1_neg ) R_1X_LL w=1e-07 l=1e-07   \
 res=0.149966
XXI2\<7\>\/XI2\<4\>\/RR0 (  N_SEL0\<4\>_XI2\<7\>\/XI2\<4\>\/RR0_pos \
 N_WLSEL\<232\>_XI2\<7\>\/XI2\<4\>\/RR0_neg ) R_1X_LL w=1e-07 l=1e-07   \
 res=0.149966
XXI2\<7\>\/XI2\<3\>\/RR1 (  N_SEL1\<7\>_XI2\<7\>\/XI2\<3\>\/RR1_pos \
 N_WLSEL\<231\>_XI2\<7\>\/XI2\<3\>\/RR1_neg ) R_1X_LL w=1e-07 l=1e-07   \
 res=0.149966
XXI2\<7\>\/XI2\<3\>\/RR0 (  N_SEL0\<3\>_XI2\<7\>\/XI2\<3\>\/RR0_pos \
 N_WLSEL\<230\>_XI2\<7\>\/XI2\<3\>\/RR0_neg ) R_1X_LL w=1e-07 l=1e-07   \
 res=0.149966
XXI2\<7\>\/XI2\<2\>\/RR1 (  N_SEL1\<7\>_XI2\<7\>\/XI2\<2\>\/RR1_pos \
 N_WLSEL\<229\>_XI2\<7\>\/XI2\<2\>\/RR1_neg ) R_1X_LL w=1e-07 l=1e-07   \
 res=0.149966
XXI2\<7\>\/XI2\<2\>\/RR0 (  N_SEL0\<2\>_XI2\<7\>\/XI2\<2\>\/RR0_pos \
 N_WLSEL\<228\>_XI2\<7\>\/XI2\<2\>\/RR0_neg ) R_1X_LL w=1e-07 l=1e-07   \
 res=0.149966
XXI2\<7\>\/XI2\<1\>\/RR1 (  N_SEL1\<7\>_XI2\<7\>\/XI2\<1\>\/RR1_pos \
 N_WLSEL\<227\>_XI2\<7\>\/XI2\<1\>\/RR1_neg ) R_1X_LL w=1e-07 l=1e-07   \
 res=0.149966
XXI2\<7\>\/XI2\<1\>\/RR0 (  N_SEL0\<1\>_XI2\<7\>\/XI2\<1\>\/RR0_pos \
 N_WLSEL\<226\>_XI2\<7\>\/XI2\<1\>\/RR0_neg ) R_1X_LL w=1e-07 l=1e-07   \
 res=0.149966
XXI2\<7\>\/XI2\<0\>\/RR1 (  N_SEL1\<7\>_XI2\<7\>\/XI2\<0\>\/RR1_pos \
 N_WLSEL\<225\>_XI2\<7\>\/XI2\<0\>\/RR1_neg ) R_1X_LL w=1e-07 l=1e-07   \
 res=0.149966
XXI2\<7\>\/XI2\<0\>\/RR0 (  N_SEL0\<0\>_XI2\<7\>\/XI2\<0\>\/RR0_pos \
 N_WLSEL\<224\>_XI2\<7\>\/XI2\<0\>\/RR0_neg ) R_1X_LL w=1e-07 l=1e-07   \
 res=0.149966
XXI2\<6\>\/XI2\<15\>\/RR1 (  N_SEL1\<6\>_XI2\<6\>\/XI2\<15\>\/RR1_pos \
 N_WLSEL\<223\>_XI2\<6\>\/XI2\<15\>\/RR1_neg ) R_1X_LL w=1e-07 l=1e-07   \
 res=0.149966
XXI2\<6\>\/XI2\<15\>\/RR0 (  N_SEL0\<15\>_XI2\<6\>\/XI2\<15\>\/RR0_pos \
 N_WLSEL\<222\>_XI2\<6\>\/XI2\<15\>\/RR0_neg ) R_1X_LL w=1e-07 l=1e-07   \
 res=0.149966
XXI2\<6\>\/XI2\<14\>\/RR1 (  N_SEL1\<6\>_XI2\<6\>\/XI2\<14\>\/RR1_pos \
 N_WLSEL\<221\>_XI2\<6\>\/XI2\<14\>\/RR1_neg ) R_1X_LL w=1e-07 l=1e-07   \
 res=0.149966
XXI2\<6\>\/XI2\<14\>\/RR0 (  N_SEL0\<14\>_XI2\<6\>\/XI2\<14\>\/RR0_pos \
 N_WLSEL\<220\>_XI2\<6\>\/XI2\<14\>\/RR0_neg ) R_1X_LL w=1e-07 l=1e-07   \
 res=0.149966
XXI2\<6\>\/XI2\<13\>\/RR1 (  N_SEL1\<6\>_XI2\<6\>\/XI2\<13\>\/RR1_pos \
 N_WLSEL\<219\>_XI2\<6\>\/XI2\<13\>\/RR1_neg ) R_1X_LL w=1e-07 l=1e-07   \
 res=0.149966
XXI2\<6\>\/XI2\<13\>\/RR0 (  N_SEL0\<13\>_XI2\<6\>\/XI2\<13\>\/RR0_pos \
 N_WLSEL\<218\>_XI2\<6\>\/XI2\<13\>\/RR0_neg ) R_1X_LL w=1e-07 l=1e-07   \
 res=0.149966
XXI2\<6\>\/XI2\<12\>\/RR1 (  N_SEL1\<6\>_XI2\<6\>\/XI2\<12\>\/RR1_pos \
 N_WLSEL\<217\>_XI2\<6\>\/XI2\<12\>\/RR1_neg ) R_1X_LL w=1e-07 l=1e-07   \
 res=0.149966
XXI2\<6\>\/XI2\<12\>\/RR0 (  N_SEL0\<12\>_XI2\<6\>\/XI2\<12\>\/RR0_pos \
 N_WLSEL\<216\>_XI2\<6\>\/XI2\<12\>\/RR0_neg ) R_1X_LL w=1e-07 l=1e-07   \
 res=0.149966
XXI2\<6\>\/XI2\<11\>\/RR1 (  N_SEL1\<6\>_XI2\<6\>\/XI2\<11\>\/RR1_pos \
 N_WLSEL\<215\>_XI2\<6\>\/XI2\<11\>\/RR1_neg ) R_1X_LL w=1e-07 l=1e-07   \
 res=0.149966
XXI2\<6\>\/XI2\<11\>\/RR0 (  N_SEL0\<11\>_XI2\<6\>\/XI2\<11\>\/RR0_pos \
 N_WLSEL\<214\>_XI2\<6\>\/XI2\<11\>\/RR0_neg ) R_1X_LL w=1e-07 l=1e-07   \
 res=0.149966
XXI2\<6\>\/XI2\<10\>\/RR1 (  N_SEL1\<6\>_XI2\<6\>\/XI2\<10\>\/RR1_pos \
 N_WLSEL\<213\>_XI2\<6\>\/XI2\<10\>\/RR1_neg ) R_1X_LL w=1e-07 l=1e-07   \
 res=0.149966
XXI2\<6\>\/XI2\<10\>\/RR0 (  N_SEL0\<10\>_XI2\<6\>\/XI2\<10\>\/RR0_pos \
 N_WLSEL\<212\>_XI2\<6\>\/XI2\<10\>\/RR0_neg ) R_1X_LL w=1e-07 l=1e-07   \
 res=0.149966
XXI2\<6\>\/XI2\<9\>\/RR1 (  N_SEL1\<6\>_XI2\<6\>\/XI2\<9\>\/RR1_pos \
 N_WLSEL\<211\>_XI2\<6\>\/XI2\<9\>\/RR1_neg ) R_1X_LL w=1e-07 l=1e-07   \
 res=0.149966
XXI2\<6\>\/XI2\<9\>\/RR0 (  N_SEL0\<9\>_XI2\<6\>\/XI2\<9\>\/RR0_pos \
 N_WLSEL\<210\>_XI2\<6\>\/XI2\<9\>\/RR0_neg ) R_1X_LL w=1e-07 l=1e-07   \
 res=0.149966
XXI2\<6\>\/XI2\<8\>\/RR1 (  N_SEL1\<6\>_XI2\<6\>\/XI2\<8\>\/RR1_pos \
 N_WLSEL\<209\>_XI2\<6\>\/XI2\<8\>\/RR1_neg ) R_1X_LL w=1e-07 l=1e-07   \
 res=0.149966
XXI2\<6\>\/XI2\<8\>\/RR0 (  N_SEL0\<8\>_XI2\<6\>\/XI2\<8\>\/RR0_pos \
 N_WLSEL\<208\>_XI2\<6\>\/XI2\<8\>\/RR0_neg ) R_1X_LL w=1e-07 l=1e-07   \
 res=0.149966
XXI2\<6\>\/XI2\<7\>\/RR1 (  N_SEL1\<6\>_XI2\<6\>\/XI2\<7\>\/RR1_pos \
 N_WLSEL\<207\>_XI2\<6\>\/XI2\<7\>\/RR1_neg ) R_1X_LL w=1e-07 l=1e-07   \
 res=0.149966
XXI2\<6\>\/XI2\<7\>\/RR0 (  N_SEL0\<7\>_XI2\<6\>\/XI2\<7\>\/RR0_pos \
 N_WLSEL\<206\>_XI2\<6\>\/XI2\<7\>\/RR0_neg ) R_1X_LL w=1e-07 l=1e-07   \
 res=0.149966
XXI2\<6\>\/XI2\<6\>\/RR1 (  N_SEL1\<6\>_XI2\<6\>\/XI2\<6\>\/RR1_pos \
 N_WLSEL\<205\>_XI2\<6\>\/XI2\<6\>\/RR1_neg ) R_1X_LL w=1e-07 l=1e-07   \
 res=0.149966
XXI2\<6\>\/XI2\<6\>\/RR0 (  N_SEL0\<6\>_XI2\<6\>\/XI2\<6\>\/RR0_pos \
 N_WLSEL\<204\>_XI2\<6\>\/XI2\<6\>\/RR0_neg ) R_1X_LL w=1e-07 l=1e-07   \
 res=0.149966
XXI2\<6\>\/XI2\<5\>\/RR1 (  N_SEL1\<6\>_XI2\<6\>\/XI2\<5\>\/RR1_pos \
 N_WLSEL\<203\>_XI2\<6\>\/XI2\<5\>\/RR1_neg ) R_1X_LL w=1e-07 l=1e-07   \
 res=0.149966
XXI2\<6\>\/XI2\<5\>\/RR0 (  N_SEL0\<5\>_XI2\<6\>\/XI2\<5\>\/RR0_pos \
 N_WLSEL\<202\>_XI2\<6\>\/XI2\<5\>\/RR0_neg ) R_1X_LL w=1e-07 l=1e-07   \
 res=0.149966
XXI2\<6\>\/XI2\<4\>\/RR1 (  N_SEL1\<6\>_XI2\<6\>\/XI2\<4\>\/RR1_pos \
 N_WLSEL\<201\>_XI2\<6\>\/XI2\<4\>\/RR1_neg ) R_1X_LL w=1e-07 l=1e-07   \
 res=0.149966
XXI2\<6\>\/XI2\<4\>\/RR0 (  N_SEL0\<4\>_XI2\<6\>\/XI2\<4\>\/RR0_pos \
 N_WLSEL\<200\>_XI2\<6\>\/XI2\<4\>\/RR0_neg ) R_1X_LL w=1e-07 l=1e-07   \
 res=0.149966
XXI2\<6\>\/XI2\<3\>\/RR1 (  N_SEL1\<6\>_XI2\<6\>\/XI2\<3\>\/RR1_pos \
 N_WLSEL\<199\>_XI2\<6\>\/XI2\<3\>\/RR1_neg ) R_1X_LL w=1e-07 l=1e-07   \
 res=0.149966
XXI2\<6\>\/XI2\<3\>\/RR0 (  N_SEL0\<3\>_XI2\<6\>\/XI2\<3\>\/RR0_pos \
 N_WLSEL\<198\>_XI2\<6\>\/XI2\<3\>\/RR0_neg ) R_1X_LL w=1e-07 l=1e-07   \
 res=0.149966
XXI2\<6\>\/XI2\<2\>\/RR1 (  N_SEL1\<6\>_XI2\<6\>\/XI2\<2\>\/RR1_pos \
 N_WLSEL\<197\>_XI2\<6\>\/XI2\<2\>\/RR1_neg ) R_1X_LL w=1e-07 l=1e-07   \
 res=0.149966
XXI2\<6\>\/XI2\<2\>\/RR0 (  N_SEL0\<2\>_XI2\<6\>\/XI2\<2\>\/RR0_pos \
 N_WLSEL\<196\>_XI2\<6\>\/XI2\<2\>\/RR0_neg ) R_1X_LL w=1e-07 l=1e-07   \
 res=0.149966
XXI2\<6\>\/XI2\<1\>\/RR1 (  N_SEL1\<6\>_XI2\<6\>\/XI2\<1\>\/RR1_pos \
 N_WLSEL\<195\>_XI2\<6\>\/XI2\<1\>\/RR1_neg ) R_1X_LL w=1e-07 l=1e-07   \
 res=0.149966
XXI2\<6\>\/XI2\<1\>\/RR0 (  N_SEL0\<1\>_XI2\<6\>\/XI2\<1\>\/RR0_pos \
 N_WLSEL\<194\>_XI2\<6\>\/XI2\<1\>\/RR0_neg ) R_1X_LL w=1e-07 l=1e-07   \
 res=0.149966
XXI2\<6\>\/XI2\<0\>\/RR1 (  N_SEL1\<6\>_XI2\<6\>\/XI2\<0\>\/RR1_pos \
 N_WLSEL\<193\>_XI2\<6\>\/XI2\<0\>\/RR1_neg ) R_1X_LL w=1e-07 l=1e-07   \
 res=0.149966
XXI2\<6\>\/XI2\<0\>\/RR0 (  N_SEL0\<0\>_XI2\<6\>\/XI2\<0\>\/RR0_pos \
 N_WLSEL\<192\>_XI2\<6\>\/XI2\<0\>\/RR0_neg ) R_1X_LL w=1e-07 l=1e-07   \
 res=0.149966
XXI2\<5\>\/XI2\<15\>\/RR1 (  N_SEL1\<5\>_XI2\<5\>\/XI2\<15\>\/RR1_pos \
 N_WLSEL\<191\>_XI2\<5\>\/XI2\<15\>\/RR1_neg ) R_1X_LL w=1e-07 l=1e-07   \
 res=0.149966
XXI2\<5\>\/XI2\<15\>\/RR0 (  N_SEL0\<15\>_XI2\<5\>\/XI2\<15\>\/RR0_pos \
 N_WLSEL\<190\>_XI2\<5\>\/XI2\<15\>\/RR0_neg ) R_1X_LL w=1e-07 l=1e-07   \
 res=0.149966
XXI2\<5\>\/XI2\<14\>\/RR1 (  N_SEL1\<5\>_XI2\<5\>\/XI2\<14\>\/RR1_pos \
 N_WLSEL\<189\>_XI2\<5\>\/XI2\<14\>\/RR1_neg ) R_1X_LL w=1e-07 l=1e-07   \
 res=0.149966
XXI2\<5\>\/XI2\<14\>\/RR0 (  N_SEL0\<14\>_XI2\<5\>\/XI2\<14\>\/RR0_pos \
 N_WLSEL\<188\>_XI2\<5\>\/XI2\<14\>\/RR0_neg ) R_1X_LL w=1e-07 l=1e-07   \
 res=0.149966
XXI2\<5\>\/XI2\<13\>\/RR1 (  N_SEL1\<5\>_XI2\<5\>\/XI2\<13\>\/RR1_pos \
 N_WLSEL\<187\>_XI2\<5\>\/XI2\<13\>\/RR1_neg ) R_1X_LL w=1e-07 l=1e-07   \
 res=0.149966
XXI2\<5\>\/XI2\<13\>\/RR0 (  N_SEL0\<13\>_XI2\<5\>\/XI2\<13\>\/RR0_pos \
 N_WLSEL\<186\>_XI2\<5\>\/XI2\<13\>\/RR0_neg ) R_1X_LL w=1e-07 l=1e-07   \
 res=0.149966
XXI2\<5\>\/XI2\<12\>\/RR1 (  N_SEL1\<5\>_XI2\<5\>\/XI2\<12\>\/RR1_pos \
 N_WLSEL\<185\>_XI2\<5\>\/XI2\<12\>\/RR1_neg ) R_1X_LL w=1e-07 l=1e-07   \
 res=0.149966
XXI2\<5\>\/XI2\<12\>\/RR0 (  N_SEL0\<12\>_XI2\<5\>\/XI2\<12\>\/RR0_pos \
 N_WLSEL\<184\>_XI2\<5\>\/XI2\<12\>\/RR0_neg ) R_1X_LL w=1e-07 l=1e-07   \
 res=0.149966
XXI2\<5\>\/XI2\<11\>\/RR1 (  N_SEL1\<5\>_XI2\<5\>\/XI2\<11\>\/RR1_pos \
 N_WLSEL\<183\>_XI2\<5\>\/XI2\<11\>\/RR1_neg ) R_1X_LL w=1e-07 l=1e-07   \
 res=0.149966
XXI2\<5\>\/XI2\<11\>\/RR0 (  N_SEL0\<11\>_XI2\<5\>\/XI2\<11\>\/RR0_pos \
 N_WLSEL\<182\>_XI2\<5\>\/XI2\<11\>\/RR0_neg ) R_1X_LL w=1e-07 l=1e-07   \
 res=0.149966
XXI2\<5\>\/XI2\<10\>\/RR1 (  N_SEL1\<5\>_XI2\<5\>\/XI2\<10\>\/RR1_pos \
 N_WLSEL\<181\>_XI2\<5\>\/XI2\<10\>\/RR1_neg ) R_1X_LL w=1e-07 l=1e-07   \
 res=0.149966
XXI2\<5\>\/XI2\<10\>\/RR0 (  N_SEL0\<10\>_XI2\<5\>\/XI2\<10\>\/RR0_pos \
 N_WLSEL\<180\>_XI2\<5\>\/XI2\<10\>\/RR0_neg ) R_1X_LL w=1e-07 l=1e-07   \
 res=0.149966
XXI2\<5\>\/XI2\<9\>\/RR1 (  N_SEL1\<5\>_XI2\<5\>\/XI2\<9\>\/RR1_pos \
 N_WLSEL\<179\>_XI2\<5\>\/XI2\<9\>\/RR1_neg ) R_1X_LL w=1e-07 l=1e-07   \
 res=0.149966
XXI2\<5\>\/XI2\<9\>\/RR0 (  N_SEL0\<9\>_XI2\<5\>\/XI2\<9\>\/RR0_pos \
 N_WLSEL\<178\>_XI2\<5\>\/XI2\<9\>\/RR0_neg ) R_1X_LL w=1e-07 l=1e-07   \
 res=0.149966
XXI2\<5\>\/XI2\<8\>\/RR1 (  N_SEL1\<5\>_XI2\<5\>\/XI2\<8\>\/RR1_pos \
 N_WLSEL\<177\>_XI2\<5\>\/XI2\<8\>\/RR1_neg ) R_1X_LL w=1e-07 l=1e-07   \
 res=0.149966
XXI2\<5\>\/XI2\<8\>\/RR0 (  N_SEL0\<8\>_XI2\<5\>\/XI2\<8\>\/RR0_pos \
 N_WLSEL\<176\>_XI2\<5\>\/XI2\<8\>\/RR0_neg ) R_1X_LL w=1e-07 l=1e-07   \
 res=0.149966
XXI2\<5\>\/XI2\<7\>\/RR1 (  N_SEL1\<5\>_XI2\<5\>\/XI2\<7\>\/RR1_pos \
 N_WLSEL\<175\>_XI2\<5\>\/XI2\<7\>\/RR1_neg ) R_1X_LL w=1e-07 l=1e-07   \
 res=0.149966
XXI2\<5\>\/XI2\<7\>\/RR0 (  N_SEL0\<7\>_XI2\<5\>\/XI2\<7\>\/RR0_pos \
 N_WLSEL\<174\>_XI2\<5\>\/XI2\<7\>\/RR0_neg ) R_1X_LL w=1e-07 l=1e-07   \
 res=0.149966
XXI2\<5\>\/XI2\<6\>\/RR1 (  N_SEL1\<5\>_XI2\<5\>\/XI2\<6\>\/RR1_pos \
 N_WLSEL\<173\>_XI2\<5\>\/XI2\<6\>\/RR1_neg ) R_1X_LL w=1e-07 l=1e-07   \
 res=0.149966
XXI2\<5\>\/XI2\<6\>\/RR0 (  N_SEL0\<6\>_XI2\<5\>\/XI2\<6\>\/RR0_pos \
 N_WLSEL\<172\>_XI2\<5\>\/XI2\<6\>\/RR0_neg ) R_1X_LL w=1e-07 l=1e-07   \
 res=0.149966
XXI2\<5\>\/XI2\<5\>\/RR1 (  N_SEL1\<5\>_XI2\<5\>\/XI2\<5\>\/RR1_pos \
 N_WLSEL\<171\>_XI2\<5\>\/XI2\<5\>\/RR1_neg ) R_1X_LL w=1e-07 l=1e-07   \
 res=0.149966
XXI2\<5\>\/XI2\<5\>\/RR0 (  N_SEL0\<5\>_XI2\<5\>\/XI2\<5\>\/RR0_pos \
 N_WLSEL\<170\>_XI2\<5\>\/XI2\<5\>\/RR0_neg ) R_1X_LL w=1e-07 l=1e-07   \
 res=0.149966
XXI2\<5\>\/XI2\<4\>\/RR1 (  N_SEL1\<5\>_XI2\<5\>\/XI2\<4\>\/RR1_pos \
 N_WLSEL\<169\>_XI2\<5\>\/XI2\<4\>\/RR1_neg ) R_1X_LL w=1e-07 l=1e-07   \
 res=0.149966
XXI2\<5\>\/XI2\<4\>\/RR0 (  N_SEL0\<4\>_XI2\<5\>\/XI2\<4\>\/RR0_pos \
 N_WLSEL\<168\>_XI2\<5\>\/XI2\<4\>\/RR0_neg ) R_1X_LL w=1e-07 l=1e-07   \
 res=0.149966
XXI2\<5\>\/XI2\<3\>\/RR1 (  N_SEL1\<5\>_XI2\<5\>\/XI2\<3\>\/RR1_pos \
 N_WLSEL\<167\>_XI2\<5\>\/XI2\<3\>\/RR1_neg ) R_1X_LL w=1e-07 l=1e-07   \
 res=0.149966
XXI2\<5\>\/XI2\<3\>\/RR0 (  N_SEL0\<3\>_XI2\<5\>\/XI2\<3\>\/RR0_pos \
 N_WLSEL\<166\>_XI2\<5\>\/XI2\<3\>\/RR0_neg ) R_1X_LL w=1e-07 l=1e-07   \
 res=0.149966
XXI2\<5\>\/XI2\<2\>\/RR1 (  N_SEL1\<5\>_XI2\<5\>\/XI2\<2\>\/RR1_pos \
 N_WLSEL\<165\>_XI2\<5\>\/XI2\<2\>\/RR1_neg ) R_1X_LL w=1e-07 l=1e-07   \
 res=0.149966
XXI2\<5\>\/XI2\<2\>\/RR0 (  N_SEL0\<2\>_XI2\<5\>\/XI2\<2\>\/RR0_pos \
 N_WLSEL\<164\>_XI2\<5\>\/XI2\<2\>\/RR0_neg ) R_1X_LL w=1e-07 l=1e-07   \
 res=0.149966
XXI2\<5\>\/XI2\<1\>\/RR1 (  N_SEL1\<5\>_XI2\<5\>\/XI2\<1\>\/RR1_pos \
 N_WLSEL\<163\>_XI2\<5\>\/XI2\<1\>\/RR1_neg ) R_1X_LL w=1e-07 l=1e-07   \
 res=0.149966
XXI2\<5\>\/XI2\<1\>\/RR0 (  N_SEL0\<1\>_XI2\<5\>\/XI2\<1\>\/RR0_pos \
 N_WLSEL\<162\>_XI2\<5\>\/XI2\<1\>\/RR0_neg ) R_1X_LL w=1e-07 l=1e-07   \
 res=0.149966
XXI2\<5\>\/XI2\<0\>\/RR1 (  N_SEL1\<5\>_XI2\<5\>\/XI2\<0\>\/RR1_pos \
 N_WLSEL\<161\>_XI2\<5\>\/XI2\<0\>\/RR1_neg ) R_1X_LL w=1e-07 l=1e-07   \
 res=0.149966
XXI2\<5\>\/XI2\<0\>\/RR0 (  N_SEL0\<0\>_XI2\<5\>\/XI2\<0\>\/RR0_pos \
 N_WLSEL\<160\>_XI2\<5\>\/XI2\<0\>\/RR0_neg ) R_1X_LL w=1e-07 l=1e-07   \
 res=0.149966
XXI2\<4\>\/XI2\<15\>\/RR1 (  N_SEL1\<4\>_XI2\<4\>\/XI2\<15\>\/RR1_pos \
 N_WLSEL\<159\>_XI2\<4\>\/XI2\<15\>\/RR1_neg ) R_1X_LL w=1e-07 l=1e-07   \
 res=0.149966
XXI2\<4\>\/XI2\<15\>\/RR0 (  N_SEL0\<15\>_XI2\<4\>\/XI2\<15\>\/RR0_pos \
 N_WLSEL\<158\>_XI2\<4\>\/XI2\<15\>\/RR0_neg ) R_1X_LL w=1e-07 l=1e-07   \
 res=0.149966
XXI2\<4\>\/XI2\<14\>\/RR1 (  N_SEL1\<4\>_XI2\<4\>\/XI2\<14\>\/RR1_pos \
 N_WLSEL\<157\>_XI2\<4\>\/XI2\<14\>\/RR1_neg ) R_1X_LL w=1e-07 l=1e-07   \
 res=0.149966
XXI2\<4\>\/XI2\<14\>\/RR0 (  N_SEL0\<14\>_XI2\<4\>\/XI2\<14\>\/RR0_pos \
 N_WLSEL\<156\>_XI2\<4\>\/XI2\<14\>\/RR0_neg ) R_1X_LL w=1e-07 l=1e-07   \
 res=0.149966
XXI2\<4\>\/XI2\<13\>\/RR1 (  N_SEL1\<4\>_XI2\<4\>\/XI2\<13\>\/RR1_pos \
 N_WLSEL\<155\>_XI2\<4\>\/XI2\<13\>\/RR1_neg ) R_1X_LL w=1e-07 l=1e-07   \
 res=0.149966
XXI2\<4\>\/XI2\<13\>\/RR0 (  N_SEL0\<13\>_XI2\<4\>\/XI2\<13\>\/RR0_pos \
 N_WLSEL\<154\>_XI2\<4\>\/XI2\<13\>\/RR0_neg ) R_1X_LL w=1e-07 l=1e-07   \
 res=0.149966
XXI2\<4\>\/XI2\<12\>\/RR1 (  N_SEL1\<4\>_XI2\<4\>\/XI2\<12\>\/RR1_pos \
 N_WLSEL\<153\>_XI2\<4\>\/XI2\<12\>\/RR1_neg ) R_1X_LL w=1e-07 l=1e-07   \
 res=0.149966
XXI2\<4\>\/XI2\<12\>\/RR0 (  N_SEL0\<12\>_XI2\<4\>\/XI2\<12\>\/RR0_pos \
 N_WLSEL\<152\>_XI2\<4\>\/XI2\<12\>\/RR0_neg ) R_1X_LL w=1e-07 l=1e-07   \
 res=0.149966
XXI2\<4\>\/XI2\<11\>\/RR1 (  N_SEL1\<4\>_XI2\<4\>\/XI2\<11\>\/RR1_pos \
 N_WLSEL\<151\>_XI2\<4\>\/XI2\<11\>\/RR1_neg ) R_1X_LL w=1e-07 l=1e-07   \
 res=0.149966
XXI2\<4\>\/XI2\<11\>\/RR0 (  N_SEL0\<11\>_XI2\<4\>\/XI2\<11\>\/RR0_pos \
 N_WLSEL\<150\>_XI2\<4\>\/XI2\<11\>\/RR0_neg ) R_1X_LL w=1e-07 l=1e-07   \
 res=0.149966
XXI2\<4\>\/XI2\<10\>\/RR1 (  N_SEL1\<4\>_XI2\<4\>\/XI2\<10\>\/RR1_pos \
 N_WLSEL\<149\>_XI2\<4\>\/XI2\<10\>\/RR1_neg ) R_1X_LL w=1e-07 l=1e-07   \
 res=0.149966
XXI2\<4\>\/XI2\<10\>\/RR0 (  N_SEL0\<10\>_XI2\<4\>\/XI2\<10\>\/RR0_pos \
 N_WLSEL\<148\>_XI2\<4\>\/XI2\<10\>\/RR0_neg ) R_1X_LL w=1e-07 l=1e-07   \
 res=0.149966
XXI2\<4\>\/XI2\<9\>\/RR1 (  N_SEL1\<4\>_XI2\<4\>\/XI2\<9\>\/RR1_pos \
 N_WLSEL\<147\>_XI2\<4\>\/XI2\<9\>\/RR1_neg ) R_1X_LL w=1e-07 l=1e-07   \
 res=0.149966
XXI2\<4\>\/XI2\<9\>\/RR0 (  N_SEL0\<9\>_XI2\<4\>\/XI2\<9\>\/RR0_pos \
 N_WLSEL\<146\>_XI2\<4\>\/XI2\<9\>\/RR0_neg ) R_1X_LL w=1e-07 l=1e-07   \
 res=0.149966
XXI2\<4\>\/XI2\<8\>\/RR1 (  N_SEL1\<4\>_XI2\<4\>\/XI2\<8\>\/RR1_pos \
 N_WLSEL\<145\>_XI2\<4\>\/XI2\<8\>\/RR1_neg ) R_1X_LL w=1e-07 l=1e-07   \
 res=0.149966
XXI2\<4\>\/XI2\<8\>\/RR0 (  N_SEL0\<8\>_XI2\<4\>\/XI2\<8\>\/RR0_pos \
 N_WLSEL\<144\>_XI2\<4\>\/XI2\<8\>\/RR0_neg ) R_1X_LL w=1e-07 l=1e-07   \
 res=0.149966
XXI2\<4\>\/XI2\<7\>\/RR1 (  N_SEL1\<4\>_XI2\<4\>\/XI2\<7\>\/RR1_pos \
 N_WLSEL\<143\>_XI2\<4\>\/XI2\<7\>\/RR1_neg ) R_1X_LL w=1e-07 l=1e-07   \
 res=0.149966
XXI2\<4\>\/XI2\<7\>\/RR0 (  N_SEL0\<7\>_XI2\<4\>\/XI2\<7\>\/RR0_pos \
 N_WLSEL\<142\>_XI2\<4\>\/XI2\<7\>\/RR0_neg ) R_1X_LL w=1e-07 l=1e-07   \
 res=0.149966
XXI2\<4\>\/XI2\<6\>\/RR1 (  N_SEL1\<4\>_XI2\<4\>\/XI2\<6\>\/RR1_pos \
 N_WLSEL\<141\>_XI2\<4\>\/XI2\<6\>\/RR1_neg ) R_1X_LL w=1e-07 l=1e-07   \
 res=0.149966
XXI2\<4\>\/XI2\<6\>\/RR0 (  N_SEL0\<6\>_XI2\<4\>\/XI2\<6\>\/RR0_pos \
 N_WLSEL\<140\>_XI2\<4\>\/XI2\<6\>\/RR0_neg ) R_1X_LL w=1e-07 l=1e-07   \
 res=0.149966
XXI2\<4\>\/XI2\<5\>\/RR1 (  N_SEL1\<4\>_XI2\<4\>\/XI2\<5\>\/RR1_pos \
 N_WLSEL\<139\>_XI2\<4\>\/XI2\<5\>\/RR1_neg ) R_1X_LL w=1e-07 l=1e-07   \
 res=0.149966
XXI2\<4\>\/XI2\<5\>\/RR0 (  N_SEL0\<5\>_XI2\<4\>\/XI2\<5\>\/RR0_pos \
 N_WLSEL\<138\>_XI2\<4\>\/XI2\<5\>\/RR0_neg ) R_1X_LL w=1e-07 l=1e-07   \
 res=0.149966
XXI2\<4\>\/XI2\<4\>\/RR1 (  N_SEL1\<4\>_XI2\<4\>\/XI2\<4\>\/RR1_pos \
 N_WLSEL\<137\>_XI2\<4\>\/XI2\<4\>\/RR1_neg ) R_1X_LL w=1e-07 l=1e-07   \
 res=0.149966
XXI2\<4\>\/XI2\<4\>\/RR0 (  N_SEL0\<4\>_XI2\<4\>\/XI2\<4\>\/RR0_pos \
 N_WLSEL\<136\>_XI2\<4\>\/XI2\<4\>\/RR0_neg ) R_1X_LL w=1e-07 l=1e-07   \
 res=0.149966
XXI2\<4\>\/XI2\<3\>\/RR1 (  N_SEL1\<4\>_XI2\<4\>\/XI2\<3\>\/RR1_pos \
 N_WLSEL\<135\>_XI2\<4\>\/XI2\<3\>\/RR1_neg ) R_1X_LL w=1e-07 l=1e-07   \
 res=0.149966
XXI2\<4\>\/XI2\<3\>\/RR0 (  N_SEL0\<3\>_XI2\<4\>\/XI2\<3\>\/RR0_pos \
 N_WLSEL\<134\>_XI2\<4\>\/XI2\<3\>\/RR0_neg ) R_1X_LL w=1e-07 l=1e-07   \
 res=0.149966
XXI2\<4\>\/XI2\<2\>\/RR1 (  N_SEL1\<4\>_XI2\<4\>\/XI2\<2\>\/RR1_pos \
 N_WLSEL\<133\>_XI2\<4\>\/XI2\<2\>\/RR1_neg ) R_1X_LL w=1e-07 l=1e-07   \
 res=0.149966
XXI2\<4\>\/XI2\<2\>\/RR0 (  N_SEL0\<2\>_XI2\<4\>\/XI2\<2\>\/RR0_pos \
 N_WLSEL\<132\>_XI2\<4\>\/XI2\<2\>\/RR0_neg ) R_1X_LL w=1e-07 l=1e-07   \
 res=0.149966
XXI2\<4\>\/XI2\<1\>\/RR1 (  N_SEL1\<4\>_XI2\<4\>\/XI2\<1\>\/RR1_pos \
 N_WLSEL\<131\>_XI2\<4\>\/XI2\<1\>\/RR1_neg ) R_1X_LL w=1e-07 l=1e-07   \
 res=0.149966
XXI2\<4\>\/XI2\<1\>\/RR0 (  N_SEL0\<1\>_XI2\<4\>\/XI2\<1\>\/RR0_pos \
 N_WLSEL\<130\>_XI2\<4\>\/XI2\<1\>\/RR0_neg ) R_1X_LL w=1e-07 l=1e-07   \
 res=0.149966
XXI2\<4\>\/XI2\<0\>\/RR1 (  N_SEL1\<4\>_XI2\<4\>\/XI2\<0\>\/RR1_pos \
 N_WLSEL\<129\>_XI2\<4\>\/XI2\<0\>\/RR1_neg ) R_1X_LL w=1e-07 l=1e-07   \
 res=0.149966
XXI2\<4\>\/XI2\<0\>\/RR0 (  N_SEL0\<0\>_XI2\<4\>\/XI2\<0\>\/RR0_pos \
 N_WLSEL\<128\>_XI2\<4\>\/XI2\<0\>\/RR0_neg ) R_1X_LL w=1e-07 l=1e-07   \
 res=0.149966
XXI2\<3\>\/XI2\<15\>\/RR1 (  N_SEL1\<3\>_XI2\<3\>\/XI2\<15\>\/RR1_pos \
 N_WLSEL\<127\>_XI2\<3\>\/XI2\<15\>\/RR1_neg ) R_1X_LL w=1e-07 l=1e-07   \
 res=0.149966
XXI2\<3\>\/XI2\<15\>\/RR0 (  N_SEL0\<15\>_XI2\<3\>\/XI2\<15\>\/RR0_pos \
 N_WLSEL\<126\>_XI2\<3\>\/XI2\<15\>\/RR0_neg ) R_1X_LL w=1e-07 l=1e-07   \
 res=0.149966
XXI2\<3\>\/XI2\<14\>\/RR1 (  N_SEL1\<3\>_XI2\<3\>\/XI2\<14\>\/RR1_pos \
 N_WLSEL\<125\>_XI2\<3\>\/XI2\<14\>\/RR1_neg ) R_1X_LL w=1e-07 l=1e-07   \
 res=0.149966
XXI2\<3\>\/XI2\<14\>\/RR0 (  N_SEL0\<14\>_XI2\<3\>\/XI2\<14\>\/RR0_pos \
 N_WLSEL\<124\>_XI2\<3\>\/XI2\<14\>\/RR0_neg ) R_1X_LL w=1e-07 l=1e-07   \
 res=0.149966
XXI2\<3\>\/XI2\<13\>\/RR1 (  N_SEL1\<3\>_XI2\<3\>\/XI2\<13\>\/RR1_pos \
 N_WLSEL\<123\>_XI2\<3\>\/XI2\<13\>\/RR1_neg ) R_1X_LL w=1e-07 l=1e-07   \
 res=0.149966
XXI2\<3\>\/XI2\<13\>\/RR0 (  N_SEL0\<13\>_XI2\<3\>\/XI2\<13\>\/RR0_pos \
 N_WLSEL\<122\>_XI2\<3\>\/XI2\<13\>\/RR0_neg ) R_1X_LL w=1e-07 l=1e-07   \
 res=0.149966
XXI2\<3\>\/XI2\<12\>\/RR1 (  N_SEL1\<3\>_XI2\<3\>\/XI2\<12\>\/RR1_pos \
 N_WLSEL\<121\>_XI2\<3\>\/XI2\<12\>\/RR1_neg ) R_1X_LL w=1e-07 l=1e-07   \
 res=0.149966
XXI2\<3\>\/XI2\<12\>\/RR0 (  N_SEL0\<12\>_XI2\<3\>\/XI2\<12\>\/RR0_pos \
 N_WLSEL\<120\>_XI2\<3\>\/XI2\<12\>\/RR0_neg ) R_1X_LL w=1e-07 l=1e-07   \
 res=0.149966
XXI2\<3\>\/XI2\<11\>\/RR1 (  N_SEL1\<3\>_XI2\<3\>\/XI2\<11\>\/RR1_pos \
 N_WLSEL\<119\>_XI2\<3\>\/XI2\<11\>\/RR1_neg ) R_1X_LL w=1e-07 l=1e-07   \
 res=0.149966
XXI2\<3\>\/XI2\<11\>\/RR0 (  N_SEL0\<11\>_XI2\<3\>\/XI2\<11\>\/RR0_pos \
 N_WLSEL\<118\>_XI2\<3\>\/XI2\<11\>\/RR0_neg ) R_1X_LL w=1e-07 l=1e-07   \
 res=0.149966
XXI2\<3\>\/XI2\<10\>\/RR1 (  N_SEL1\<3\>_XI2\<3\>\/XI2\<10\>\/RR1_pos \
 N_WLSEL\<117\>_XI2\<3\>\/XI2\<10\>\/RR1_neg ) R_1X_LL w=1e-07 l=1e-07   \
 res=0.149966
XXI2\<3\>\/XI2\<10\>\/RR0 (  N_SEL0\<10\>_XI2\<3\>\/XI2\<10\>\/RR0_pos \
 N_WLSEL\<116\>_XI2\<3\>\/XI2\<10\>\/RR0_neg ) R_1X_LL w=1e-07 l=1e-07   \
 res=0.149966
XXI2\<3\>\/XI2\<9\>\/RR1 (  N_SEL1\<3\>_XI2\<3\>\/XI2\<9\>\/RR1_pos \
 N_WLSEL\<115\>_XI2\<3\>\/XI2\<9\>\/RR1_neg ) R_1X_LL w=1e-07 l=1e-07   \
 res=0.149966
XXI2\<3\>\/XI2\<9\>\/RR0 (  N_SEL0\<9\>_XI2\<3\>\/XI2\<9\>\/RR0_pos \
 N_WLSEL\<114\>_XI2\<3\>\/XI2\<9\>\/RR0_neg ) R_1X_LL w=1e-07 l=1e-07   \
 res=0.149966
XXI2\<3\>\/XI2\<8\>\/RR1 (  N_SEL1\<3\>_XI2\<3\>\/XI2\<8\>\/RR1_pos \
 N_WLSEL\<113\>_XI2\<3\>\/XI2\<8\>\/RR1_neg ) R_1X_LL w=1e-07 l=1e-07   \
 res=0.149966
XXI2\<3\>\/XI2\<8\>\/RR0 (  N_SEL0\<8\>_XI2\<3\>\/XI2\<8\>\/RR0_pos \
 N_WLSEL\<112\>_XI2\<3\>\/XI2\<8\>\/RR0_neg ) R_1X_LL w=1e-07 l=1e-07   \
 res=0.149966
XXI2\<3\>\/XI2\<7\>\/RR1 (  N_SEL1\<3\>_XI2\<3\>\/XI2\<7\>\/RR1_pos \
 N_WLSEL\<111\>_XI2\<3\>\/XI2\<7\>\/RR1_neg ) R_1X_LL w=1e-07 l=1e-07   \
 res=0.149966
XXI2\<3\>\/XI2\<7\>\/RR0 (  N_SEL0\<7\>_XI2\<3\>\/XI2\<7\>\/RR0_pos \
 N_WLSEL\<110\>_XI2\<3\>\/XI2\<7\>\/RR0_neg ) R_1X_LL w=1e-07 l=1e-07   \
 res=0.149966
XXI2\<3\>\/XI2\<6\>\/RR1 (  N_SEL1\<3\>_XI2\<3\>\/XI2\<6\>\/RR1_pos \
 N_WLSEL\<109\>_XI2\<3\>\/XI2\<6\>\/RR1_neg ) R_1X_LL w=1e-07 l=1e-07   \
 res=0.149966
XXI2\<3\>\/XI2\<6\>\/RR0 (  N_SEL0\<6\>_XI2\<3\>\/XI2\<6\>\/RR0_pos \
 N_WLSEL\<108\>_XI2\<3\>\/XI2\<6\>\/RR0_neg ) R_1X_LL w=1e-07 l=1e-07   \
 res=0.149966
XXI2\<3\>\/XI2\<5\>\/RR1 (  N_SEL1\<3\>_XI2\<3\>\/XI2\<5\>\/RR1_pos \
 N_WLSEL\<107\>_XI2\<3\>\/XI2\<5\>\/RR1_neg ) R_1X_LL w=1e-07 l=1e-07   \
 res=0.149966
XXI2\<3\>\/XI2\<5\>\/RR0 (  N_SEL0\<5\>_XI2\<3\>\/XI2\<5\>\/RR0_pos \
 N_WLSEL\<106\>_XI2\<3\>\/XI2\<5\>\/RR0_neg ) R_1X_LL w=1e-07 l=1e-07   \
 res=0.149966
XXI2\<3\>\/XI2\<4\>\/RR1 (  N_SEL1\<3\>_XI2\<3\>\/XI2\<4\>\/RR1_pos \
 N_WLSEL\<105\>_XI2\<3\>\/XI2\<4\>\/RR1_neg ) R_1X_LL w=1e-07 l=1e-07   \
 res=0.149966
XXI2\<3\>\/XI2\<4\>\/RR0 (  N_SEL0\<4\>_XI2\<3\>\/XI2\<4\>\/RR0_pos \
 N_WLSEL\<104\>_XI2\<3\>\/XI2\<4\>\/RR0_neg ) R_1X_LL w=1e-07 l=1e-07   \
 res=0.149966
XXI2\<3\>\/XI2\<3\>\/RR1 (  N_SEL1\<3\>_XI2\<3\>\/XI2\<3\>\/RR1_pos \
 N_WLSEL\<103\>_XI2\<3\>\/XI2\<3\>\/RR1_neg ) R_1X_LL w=1e-07 l=1e-07   \
 res=0.149966
XXI2\<3\>\/XI2\<3\>\/RR0 (  N_SEL0\<3\>_XI2\<3\>\/XI2\<3\>\/RR0_pos \
 N_WLSEL\<102\>_XI2\<3\>\/XI2\<3\>\/RR0_neg ) R_1X_LL w=1e-07 l=1e-07   \
 res=0.149966
XXI2\<3\>\/XI2\<2\>\/RR1 (  N_SEL1\<3\>_XI2\<3\>\/XI2\<2\>\/RR1_pos \
 N_WLSEL\<101\>_XI2\<3\>\/XI2\<2\>\/RR1_neg ) R_1X_LL w=1e-07 l=1e-07   \
 res=0.149966
XXI2\<3\>\/XI2\<2\>\/RR0 (  N_SEL0\<2\>_XI2\<3\>\/XI2\<2\>\/RR0_pos \
 N_WLSEL\<100\>_XI2\<3\>\/XI2\<2\>\/RR0_neg ) R_1X_LL w=1e-07 l=1e-07   \
 res=0.149966
XXI2\<3\>\/XI2\<1\>\/RR1 (  N_SEL1\<3\>_XI2\<3\>\/XI2\<1\>\/RR1_pos \
 N_WLSEL\<99\>_XI2\<3\>\/XI2\<1\>\/RR1_neg ) R_1X_LL w=1e-07 l=1e-07   \
 res=0.149966
XXI2\<3\>\/XI2\<1\>\/RR0 (  N_SEL0\<1\>_XI2\<3\>\/XI2\<1\>\/RR0_pos \
 N_WLSEL\<98\>_XI2\<3\>\/XI2\<1\>\/RR0_neg ) R_1X_LL w=1e-07 l=1e-07   \
 res=0.149966
XXI2\<3\>\/XI2\<0\>\/RR1 (  N_SEL1\<3\>_XI2\<3\>\/XI2\<0\>\/RR1_pos \
 N_WLSEL\<97\>_XI2\<3\>\/XI2\<0\>\/RR1_neg ) R_1X_LL w=1e-07 l=1e-07   \
 res=0.149966
XXI2\<3\>\/XI2\<0\>\/RR0 (  N_SEL0\<0\>_XI2\<3\>\/XI2\<0\>\/RR0_pos \
 N_WLSEL\<96\>_XI2\<3\>\/XI2\<0\>\/RR0_neg ) R_1X_LL w=1e-07 l=1e-07   \
 res=0.149966
XXI2\<2\>\/XI2\<15\>\/RR1 (  N_SEL1\<2\>_XI2\<2\>\/XI2\<15\>\/RR1_pos \
 N_WLSEL\<95\>_XI2\<2\>\/XI2\<15\>\/RR1_neg ) R_1X_LL w=1e-07 l=1e-07   \
 res=0.149966
XXI2\<2\>\/XI2\<15\>\/RR0 (  N_SEL0\<15\>_XI2\<2\>\/XI2\<15\>\/RR0_pos \
 N_WLSEL\<94\>_XI2\<2\>\/XI2\<15\>\/RR0_neg ) R_1X_LL w=1e-07 l=1e-07   \
 res=0.149966
XXI2\<2\>\/XI2\<14\>\/RR1 (  N_SEL1\<2\>_XI2\<2\>\/XI2\<14\>\/RR1_pos \
 N_WLSEL\<93\>_XI2\<2\>\/XI2\<14\>\/RR1_neg ) R_1X_LL w=1e-07 l=1e-07   \
 res=0.149966
XXI2\<2\>\/XI2\<14\>\/RR0 (  N_SEL0\<14\>_XI2\<2\>\/XI2\<14\>\/RR0_pos \
 N_WLSEL\<92\>_XI2\<2\>\/XI2\<14\>\/RR0_neg ) R_1X_LL w=1e-07 l=1e-07   \
 res=0.149966
XXI2\<2\>\/XI2\<13\>\/RR1 (  N_SEL1\<2\>_XI2\<2\>\/XI2\<13\>\/RR1_pos \
 N_WLSEL\<91\>_XI2\<2\>\/XI2\<13\>\/RR1_neg ) R_1X_LL w=1e-07 l=1e-07   \
 res=0.149966
XXI2\<2\>\/XI2\<13\>\/RR0 (  N_SEL0\<13\>_XI2\<2\>\/XI2\<13\>\/RR0_pos \
 N_WLSEL\<90\>_XI2\<2\>\/XI2\<13\>\/RR0_neg ) R_1X_LL w=1e-07 l=1e-07   \
 res=0.149966
XXI2\<2\>\/XI2\<12\>\/RR1 (  N_SEL1\<2\>_XI2\<2\>\/XI2\<12\>\/RR1_pos \
 N_WLSEL\<89\>_XI2\<2\>\/XI2\<12\>\/RR1_neg ) R_1X_LL w=1e-07 l=1e-07   \
 res=0.149966
XXI2\<2\>\/XI2\<12\>\/RR0 (  N_SEL0\<12\>_XI2\<2\>\/XI2\<12\>\/RR0_pos \
 N_WLSEL\<88\>_XI2\<2\>\/XI2\<12\>\/RR0_neg ) R_1X_LL w=1e-07 l=1e-07   \
 res=0.149966
XXI2\<2\>\/XI2\<11\>\/RR1 (  N_SEL1\<2\>_XI2\<2\>\/XI2\<11\>\/RR1_pos \
 N_WLSEL\<87\>_XI2\<2\>\/XI2\<11\>\/RR1_neg ) R_1X_LL w=1e-07 l=1e-07   \
 res=0.149966
XXI2\<2\>\/XI2\<11\>\/RR0 (  N_SEL0\<11\>_XI2\<2\>\/XI2\<11\>\/RR0_pos \
 N_WLSEL\<86\>_XI2\<2\>\/XI2\<11\>\/RR0_neg ) R_1X_LL w=1e-07 l=1e-07   \
 res=0.149966
XXI2\<2\>\/XI2\<10\>\/RR1 (  N_SEL1\<2\>_XI2\<2\>\/XI2\<10\>\/RR1_pos \
 N_WLSEL\<85\>_XI2\<2\>\/XI2\<10\>\/RR1_neg ) R_1X_LL w=1e-07 l=1e-07   \
 res=0.149966
XXI2\<2\>\/XI2\<10\>\/RR0 (  N_SEL0\<10\>_XI2\<2\>\/XI2\<10\>\/RR0_pos \
 N_WLSEL\<84\>_XI2\<2\>\/XI2\<10\>\/RR0_neg ) R_1X_LL w=1e-07 l=1e-07   \
 res=0.149966
XXI2\<2\>\/XI2\<9\>\/RR1 (  N_SEL1\<2\>_XI2\<2\>\/XI2\<9\>\/RR1_pos \
 N_WLSEL\<83\>_XI2\<2\>\/XI2\<9\>\/RR1_neg ) R_1X_LL w=1e-07 l=1e-07   \
 res=0.149966
XXI2\<2\>\/XI2\<9\>\/RR0 (  N_SEL0\<9\>_XI2\<2\>\/XI2\<9\>\/RR0_pos \
 N_WLSEL\<82\>_XI2\<2\>\/XI2\<9\>\/RR0_neg ) R_1X_LL w=1e-07 l=1e-07   \
 res=0.149966
XXI2\<2\>\/XI2\<8\>\/RR1 (  N_SEL1\<2\>_XI2\<2\>\/XI2\<8\>\/RR1_pos \
 N_WLSEL\<81\>_XI2\<2\>\/XI2\<8\>\/RR1_neg ) R_1X_LL w=1e-07 l=1e-07   \
 res=0.149966
XXI2\<2\>\/XI2\<8\>\/RR0 (  N_SEL0\<8\>_XI2\<2\>\/XI2\<8\>\/RR0_pos \
 N_WLSEL\<80\>_XI2\<2\>\/XI2\<8\>\/RR0_neg ) R_1X_LL w=1e-07 l=1e-07   \
 res=0.149966
XXI2\<2\>\/XI2\<7\>\/RR1 (  N_SEL1\<2\>_XI2\<2\>\/XI2\<7\>\/RR1_pos \
 N_WLSEL\<79\>_XI2\<2\>\/XI2\<7\>\/RR1_neg ) R_1X_LL w=1e-07 l=1e-07   \
 res=0.149966
XXI2\<2\>\/XI2\<7\>\/RR0 (  N_SEL0\<7\>_XI2\<2\>\/XI2\<7\>\/RR0_pos \
 N_WLSEL\<78\>_XI2\<2\>\/XI2\<7\>\/RR0_neg ) R_1X_LL w=1e-07 l=1e-07   \
 res=0.149966
XXI2\<2\>\/XI2\<6\>\/RR1 (  N_SEL1\<2\>_XI2\<2\>\/XI2\<6\>\/RR1_pos \
 N_WLSEL\<77\>_XI2\<2\>\/XI2\<6\>\/RR1_neg ) R_1X_LL w=1e-07 l=1e-07   \
 res=0.149966
XXI2\<2\>\/XI2\<6\>\/RR0 (  N_SEL0\<6\>_XI2\<2\>\/XI2\<6\>\/RR0_pos \
 N_WLSEL\<76\>_XI2\<2\>\/XI2\<6\>\/RR0_neg ) R_1X_LL w=1e-07 l=1e-07   \
 res=0.149966
XXI2\<2\>\/XI2\<5\>\/RR1 (  N_SEL1\<2\>_XI2\<2\>\/XI2\<5\>\/RR1_pos \
 N_WLSEL\<75\>_XI2\<2\>\/XI2\<5\>\/RR1_neg ) R_1X_LL w=1e-07 l=1e-07   \
 res=0.149966
XXI2\<2\>\/XI2\<5\>\/RR0 (  N_SEL0\<5\>_XI2\<2\>\/XI2\<5\>\/RR0_pos \
 N_WLSEL\<74\>_XI2\<2\>\/XI2\<5\>\/RR0_neg ) R_1X_LL w=1e-07 l=1e-07   \
 res=0.149966
XXI2\<2\>\/XI2\<4\>\/RR1 (  N_SEL1\<2\>_XI2\<2\>\/XI2\<4\>\/RR1_pos \
 N_WLSEL\<73\>_XI2\<2\>\/XI2\<4\>\/RR1_neg ) R_1X_LL w=1e-07 l=1e-07   \
 res=0.149966
XXI2\<2\>\/XI2\<4\>\/RR0 (  N_SEL0\<4\>_XI2\<2\>\/XI2\<4\>\/RR0_pos \
 N_WLSEL\<72\>_XI2\<2\>\/XI2\<4\>\/RR0_neg ) R_1X_LL w=1e-07 l=1e-07   \
 res=0.149966
XXI2\<2\>\/XI2\<3\>\/RR1 (  N_SEL1\<2\>_XI2\<2\>\/XI2\<3\>\/RR1_pos \
 N_WLSEL\<71\>_XI2\<2\>\/XI2\<3\>\/RR1_neg ) R_1X_LL w=1e-07 l=1e-07   \
 res=0.149966
XXI2\<2\>\/XI2\<3\>\/RR0 (  N_SEL0\<3\>_XI2\<2\>\/XI2\<3\>\/RR0_pos \
 N_WLSEL\<70\>_XI2\<2\>\/XI2\<3\>\/RR0_neg ) R_1X_LL w=1e-07 l=1e-07   \
 res=0.149966
XXI2\<2\>\/XI2\<2\>\/RR1 (  N_SEL1\<2\>_XI2\<2\>\/XI2\<2\>\/RR1_pos \
 N_WLSEL\<69\>_XI2\<2\>\/XI2\<2\>\/RR1_neg ) R_1X_LL w=1e-07 l=1e-07   \
 res=0.149966
XXI2\<2\>\/XI2\<2\>\/RR0 (  N_SEL0\<2\>_XI2\<2\>\/XI2\<2\>\/RR0_pos \
 N_WLSEL\<68\>_XI2\<2\>\/XI2\<2\>\/RR0_neg ) R_1X_LL w=1e-07 l=1e-07   \
 res=0.149966
XXI2\<2\>\/XI2\<1\>\/RR1 (  N_SEL1\<2\>_XI2\<2\>\/XI2\<1\>\/RR1_pos \
 N_WLSEL\<67\>_XI2\<2\>\/XI2\<1\>\/RR1_neg ) R_1X_LL w=1e-07 l=1e-07   \
 res=0.149966
XXI2\<2\>\/XI2\<1\>\/RR0 (  N_SEL0\<1\>_XI2\<2\>\/XI2\<1\>\/RR0_pos \
 N_WLSEL\<66\>_XI2\<2\>\/XI2\<1\>\/RR0_neg ) R_1X_LL w=1e-07 l=1e-07   \
 res=0.149966
XXI2\<2\>\/XI2\<0\>\/RR1 (  N_SEL1\<2\>_XI2\<2\>\/XI2\<0\>\/RR1_pos \
 N_WLSEL\<65\>_XI2\<2\>\/XI2\<0\>\/RR1_neg ) R_1X_LL w=1e-07 l=1e-07   \
 res=0.149966
XXI2\<2\>\/XI2\<0\>\/RR0 (  N_SEL0\<0\>_XI2\<2\>\/XI2\<0\>\/RR0_pos \
 N_WLSEL\<64\>_XI2\<2\>\/XI2\<0\>\/RR0_neg ) R_1X_LL w=1e-07 l=1e-07   \
 res=0.149966
XXI2\<1\>\/XI2\<15\>\/RR1 (  N_SEL1\<1\>_XI2\<1\>\/XI2\<15\>\/RR1_pos \
 N_WLSEL\<63\>_XI2\<1\>\/XI2\<15\>\/RR1_neg ) R_1X_LL w=1e-07 l=1e-07   \
 res=0.149966
XXI2\<1\>\/XI2\<15\>\/RR0 (  N_SEL0\<15\>_XI2\<1\>\/XI2\<15\>\/RR0_pos \
 N_WLSEL\<62\>_XI2\<1\>\/XI2\<15\>\/RR0_neg ) R_1X_LL w=1e-07 l=1e-07   \
 res=0.149966
XXI2\<1\>\/XI2\<14\>\/RR1 (  N_SEL1\<1\>_XI2\<1\>\/XI2\<14\>\/RR1_pos \
 N_WLSEL\<61\>_XI2\<1\>\/XI2\<14\>\/RR1_neg ) R_1X_LL w=1e-07 l=1e-07   \
 res=0.149966
XXI2\<1\>\/XI2\<14\>\/RR0 (  N_SEL0\<14\>_XI2\<1\>\/XI2\<14\>\/RR0_pos \
 N_WLSEL\<60\>_XI2\<1\>\/XI2\<14\>\/RR0_neg ) R_1X_LL w=1e-07 l=1e-07   \
 res=0.149966
XXI2\<1\>\/XI2\<13\>\/RR1 (  N_SEL1\<1\>_XI2\<1\>\/XI2\<13\>\/RR1_pos \
 N_WLSEL\<59\>_XI2\<1\>\/XI2\<13\>\/RR1_neg ) R_1X_LL w=1e-07 l=1e-07   \
 res=0.149966
XXI2\<1\>\/XI2\<13\>\/RR0 (  N_SEL0\<13\>_XI2\<1\>\/XI2\<13\>\/RR0_pos \
 N_WLSEL\<58\>_XI2\<1\>\/XI2\<13\>\/RR0_neg ) R_1X_LL w=1e-07 l=1e-07   \
 res=0.149966
XXI2\<1\>\/XI2\<12\>\/RR1 (  N_SEL1\<1\>_XI2\<1\>\/XI2\<12\>\/RR1_pos \
 N_WLSEL\<57\>_XI2\<1\>\/XI2\<12\>\/RR1_neg ) R_1X_LL w=1e-07 l=1e-07   \
 res=0.149966
XXI2\<1\>\/XI2\<12\>\/RR0 (  N_SEL0\<12\>_XI2\<1\>\/XI2\<12\>\/RR0_pos \
 N_WLSEL\<56\>_XI2\<1\>\/XI2\<12\>\/RR0_neg ) R_1X_LL w=1e-07 l=1e-07   \
 res=0.149966
XXI2\<1\>\/XI2\<11\>\/RR1 (  N_SEL1\<1\>_XI2\<1\>\/XI2\<11\>\/RR1_pos \
 N_WLSEL\<55\>_XI2\<1\>\/XI2\<11\>\/RR1_neg ) R_1X_LL w=1e-07 l=1e-07   \
 res=0.149966
XXI2\<1\>\/XI2\<11\>\/RR0 (  N_SEL0\<11\>_XI2\<1\>\/XI2\<11\>\/RR0_pos \
 N_WLSEL\<54\>_XI2\<1\>\/XI2\<11\>\/RR0_neg ) R_1X_LL w=1e-07 l=1e-07   \
 res=0.149966
XXI2\<1\>\/XI2\<10\>\/RR1 (  N_SEL1\<1\>_XI2\<1\>\/XI2\<10\>\/RR1_pos \
 N_WLSEL\<53\>_XI2\<1\>\/XI2\<10\>\/RR1_neg ) R_1X_LL w=1e-07 l=1e-07   \
 res=0.149966
XXI2\<1\>\/XI2\<10\>\/RR0 (  N_SEL0\<10\>_XI2\<1\>\/XI2\<10\>\/RR0_pos \
 N_WLSEL\<52\>_XI2\<1\>\/XI2\<10\>\/RR0_neg ) R_1X_LL w=1e-07 l=1e-07   \
 res=0.149966
XXI2\<1\>\/XI2\<9\>\/RR1 (  N_SEL1\<1\>_XI2\<1\>\/XI2\<9\>\/RR1_pos \
 N_WLSEL\<51\>_XI2\<1\>\/XI2\<9\>\/RR1_neg ) R_1X_LL w=1e-07 l=1e-07   \
 res=0.149966
XXI2\<1\>\/XI2\<9\>\/RR0 (  N_SEL0\<9\>_XI2\<1\>\/XI2\<9\>\/RR0_pos \
 N_WLSEL\<50\>_XI2\<1\>\/XI2\<9\>\/RR0_neg ) R_1X_LL w=1e-07 l=1e-07   \
 res=0.149966
XXI2\<1\>\/XI2\<8\>\/RR1 (  N_SEL1\<1\>_XI2\<1\>\/XI2\<8\>\/RR1_pos \
 N_WLSEL\<49\>_XI2\<1\>\/XI2\<8\>\/RR1_neg ) R_1X_LL w=1e-07 l=1e-07   \
 res=0.149966
XXI2\<1\>\/XI2\<8\>\/RR0 (  N_SEL0\<8\>_XI2\<1\>\/XI2\<8\>\/RR0_pos \
 N_WLSEL\<48\>_XI2\<1\>\/XI2\<8\>\/RR0_neg ) R_1X_LL w=1e-07 l=1e-07   \
 res=0.149966
XXI2\<1\>\/XI2\<7\>\/RR1 (  N_SEL1\<1\>_XI2\<1\>\/XI2\<7\>\/RR1_pos \
 N_WLSEL\<47\>_XI2\<1\>\/XI2\<7\>\/RR1_neg ) R_1X_LL w=1e-07 l=1e-07   \
 res=0.149966
XXI2\<1\>\/XI2\<7\>\/RR0 (  N_SEL0\<7\>_XI2\<1\>\/XI2\<7\>\/RR0_pos \
 N_WLSEL\<46\>_XI2\<1\>\/XI2\<7\>\/RR0_neg ) R_1X_LL w=1e-07 l=1e-07   \
 res=0.149966
XXI2\<1\>\/XI2\<6\>\/RR1 (  N_SEL1\<1\>_XI2\<1\>\/XI2\<6\>\/RR1_pos \
 N_WLSEL\<45\>_XI2\<1\>\/XI2\<6\>\/RR1_neg ) R_1X_LL w=1e-07 l=1e-07   \
 res=0.149966
XXI2\<1\>\/XI2\<6\>\/RR0 (  N_SEL0\<6\>_XI2\<1\>\/XI2\<6\>\/RR0_pos \
 N_WLSEL\<44\>_XI2\<1\>\/XI2\<6\>\/RR0_neg ) R_1X_LL w=1e-07 l=1e-07   \
 res=0.149966
XXI2\<1\>\/XI2\<5\>\/RR1 (  N_SEL1\<1\>_XI2\<1\>\/XI2\<5\>\/RR1_pos \
 N_WLSEL\<43\>_XI2\<1\>\/XI2\<5\>\/RR1_neg ) R_1X_LL w=1e-07 l=1e-07   \
 res=0.149966
XXI2\<1\>\/XI2\<5\>\/RR0 (  N_SEL0\<5\>_XI2\<1\>\/XI2\<5\>\/RR0_pos \
 N_WLSEL\<42\>_XI2\<1\>\/XI2\<5\>\/RR0_neg ) R_1X_LL w=1e-07 l=1e-07   \
 res=0.149966
XXI2\<1\>\/XI2\<4\>\/RR1 (  N_SEL1\<1\>_XI2\<1\>\/XI2\<4\>\/RR1_pos \
 N_WLSEL\<41\>_XI2\<1\>\/XI2\<4\>\/RR1_neg ) R_1X_LL w=1e-07 l=1e-07   \
 res=0.149966
XXI2\<1\>\/XI2\<4\>\/RR0 (  N_SEL0\<4\>_XI2\<1\>\/XI2\<4\>\/RR0_pos \
 N_WLSEL\<40\>_XI2\<1\>\/XI2\<4\>\/RR0_neg ) R_1X_LL w=1e-07 l=1e-07   \
 res=0.149966
XXI2\<1\>\/XI2\<3\>\/RR1 (  N_SEL1\<1\>_XI2\<1\>\/XI2\<3\>\/RR1_pos \
 N_WLSEL\<39\>_XI2\<1\>\/XI2\<3\>\/RR1_neg ) R_1X_LL w=1e-07 l=1e-07   \
 res=0.149966
XXI2\<1\>\/XI2\<3\>\/RR0 (  N_SEL0\<3\>_XI2\<1\>\/XI2\<3\>\/RR0_pos \
 N_WLSEL\<38\>_XI2\<1\>\/XI2\<3\>\/RR0_neg ) R_1X_LL w=1e-07 l=1e-07   \
 res=0.149966
XXI2\<1\>\/XI2\<2\>\/RR1 (  N_SEL1\<1\>_XI2\<1\>\/XI2\<2\>\/RR1_pos \
 N_WLSEL\<37\>_XI2\<1\>\/XI2\<2\>\/RR1_neg ) R_1X_LL w=1e-07 l=1e-07   \
 res=0.149966
XXI2\<1\>\/XI2\<2\>\/RR0 (  N_SEL0\<2\>_XI2\<1\>\/XI2\<2\>\/RR0_pos \
 N_WLSEL\<36\>_XI2\<1\>\/XI2\<2\>\/RR0_neg ) R_1X_LL w=1e-07 l=1e-07   \
 res=0.149966
XXI2\<1\>\/XI2\<1\>\/RR1 (  N_SEL1\<1\>_XI2\<1\>\/XI2\<1\>\/RR1_pos \
 N_WLSEL\<35\>_XI2\<1\>\/XI2\<1\>\/RR1_neg ) R_1X_LL w=1e-07 l=1e-07   \
 res=0.149966
XXI2\<1\>\/XI2\<1\>\/RR0 (  N_SEL0\<1\>_XI2\<1\>\/XI2\<1\>\/RR0_pos \
 N_WLSEL\<34\>_XI2\<1\>\/XI2\<1\>\/RR0_neg ) R_1X_LL w=1e-07 l=1e-07   \
 res=0.149966
XXI2\<1\>\/XI2\<0\>\/RR1 (  N_SEL1\<1\>_XI2\<1\>\/XI2\<0\>\/RR1_pos \
 N_WLSEL\<33\>_XI2\<1\>\/XI2\<0\>\/RR1_neg ) R_1X_LL w=1e-07 l=1e-07   \
 res=0.149966
XXI2\<1\>\/XI2\<0\>\/RR0 (  N_SEL0\<0\>_XI2\<1\>\/XI2\<0\>\/RR0_pos \
 N_WLSEL\<32\>_XI2\<1\>\/XI2\<0\>\/RR0_neg ) R_1X_LL w=1e-07 l=1e-07   \
 res=0.149966
XXI2\<0\>\/XI2\<15\>\/RR1 (  N_SEL1\<0\>_XI2\<0\>\/XI2\<15\>\/RR1_pos \
 N_WLSEL\<31\>_XI2\<0\>\/XI2\<15\>\/RR1_neg ) R_1X_LL w=1e-07 l=1e-07   \
 res=0.149966
XXI2\<0\>\/XI2\<15\>\/RR0 (  N_SEL0\<15\>_XI2\<0\>\/XI2\<15\>\/RR0_pos \
 N_WLSEL\<30\>_XI2\<0\>\/XI2\<15\>\/RR0_neg ) R_1X_LL w=1e-07 l=1e-07   \
 res=0.149966
XXI2\<0\>\/XI2\<14\>\/RR1 (  N_SEL1\<0\>_XI2\<0\>\/XI2\<14\>\/RR1_pos \
 N_WLSEL\<29\>_XI2\<0\>\/XI2\<14\>\/RR1_neg ) R_1X_LL w=1e-07 l=1e-07   \
 res=0.149966
XXI2\<0\>\/XI2\<14\>\/RR0 (  N_SEL0\<14\>_XI2\<0\>\/XI2\<14\>\/RR0_pos \
 N_WLSEL\<28\>_XI2\<0\>\/XI2\<14\>\/RR0_neg ) R_1X_LL w=1e-07 l=1e-07   \
 res=0.149966
XXI2\<0\>\/XI2\<13\>\/RR1 (  N_SEL1\<0\>_XI2\<0\>\/XI2\<13\>\/RR1_pos \
 N_WLSEL\<27\>_XI2\<0\>\/XI2\<13\>\/RR1_neg ) R_1X_LL w=1e-07 l=1e-07   \
 res=0.149966
XXI2\<0\>\/XI2\<13\>\/RR0 (  N_SEL0\<13\>_XI2\<0\>\/XI2\<13\>\/RR0_pos \
 N_WLSEL\<26\>_XI2\<0\>\/XI2\<13\>\/RR0_neg ) R_1X_LL w=1e-07 l=1e-07   \
 res=0.149966
XXI2\<0\>\/XI2\<12\>\/RR1 (  N_SEL1\<0\>_XI2\<0\>\/XI2\<12\>\/RR1_pos \
 N_WLSEL\<25\>_XI2\<0\>\/XI2\<12\>\/RR1_neg ) R_1X_LL w=1e-07 l=1e-07   \
 res=0.149966
XXI2\<0\>\/XI2\<12\>\/RR0 (  N_SEL0\<12\>_XI2\<0\>\/XI2\<12\>\/RR0_pos \
 N_WLSEL\<24\>_XI2\<0\>\/XI2\<12\>\/RR0_neg ) R_1X_LL w=1e-07 l=1e-07   \
 res=0.149966
XXI2\<0\>\/XI2\<11\>\/RR1 (  N_SEL1\<0\>_XI2\<0\>\/XI2\<11\>\/RR1_pos \
 N_WLSEL\<23\>_XI2\<0\>\/XI2\<11\>\/RR1_neg ) R_1X_LL w=1e-07 l=1e-07   \
 res=0.149966
XXI2\<0\>\/XI2\<11\>\/RR0 (  N_SEL0\<11\>_XI2\<0\>\/XI2\<11\>\/RR0_pos \
 N_WLSEL\<22\>_XI2\<0\>\/XI2\<11\>\/RR0_neg ) R_1X_LL w=1e-07 l=1e-07   \
 res=0.149966
XXI2\<0\>\/XI2\<10\>\/RR1 (  N_SEL1\<0\>_XI2\<0\>\/XI2\<10\>\/RR1_pos \
 N_WLSEL\<21\>_XI2\<0\>\/XI2\<10\>\/RR1_neg ) R_1X_LL w=1e-07 l=1e-07   \
 res=0.149966
XXI2\<0\>\/XI2\<10\>\/RR0 (  N_SEL0\<10\>_XI2\<0\>\/XI2\<10\>\/RR0_pos \
 N_WLSEL\<20\>_XI2\<0\>\/XI2\<10\>\/RR0_neg ) R_1X_LL w=1e-07 l=1e-07   \
 res=0.149966
XXI2\<0\>\/XI2\<9\>\/RR1 (  N_SEL1\<0\>_XI2\<0\>\/XI2\<9\>\/RR1_pos \
 N_WLSEL\<19\>_XI2\<0\>\/XI2\<9\>\/RR1_neg ) R_1X_LL w=1e-07 l=1e-07   \
 res=0.149966
XXI2\<0\>\/XI2\<9\>\/RR0 (  N_SEL0\<9\>_XI2\<0\>\/XI2\<9\>\/RR0_pos \
 N_WLSEL\<18\>_XI2\<0\>\/XI2\<9\>\/RR0_neg ) R_1X_LL w=1e-07 l=1e-07   \
 res=0.149966
XXI2\<0\>\/XI2\<8\>\/RR1 (  N_SEL1\<0\>_XI2\<0\>\/XI2\<8\>\/RR1_pos \
 N_WLSEL\<17\>_XI2\<0\>\/XI2\<8\>\/RR1_neg ) R_1X_LL w=1e-07 l=1e-07   \
 res=0.149966
XXI2\<0\>\/XI2\<8\>\/RR0 (  N_SEL0\<8\>_XI2\<0\>\/XI2\<8\>\/RR0_pos \
 N_WLSEL\<16\>_XI2\<0\>\/XI2\<8\>\/RR0_neg ) R_1X_LL w=1e-07 l=1e-07   \
 res=0.149966
XXI2\<0\>\/XI2\<7\>\/RR1 (  N_SEL1\<0\>_XI2\<0\>\/XI2\<7\>\/RR1_pos \
 N_WLSEL\<15\>_XI2\<0\>\/XI2\<7\>\/RR1_neg ) R_1X_LL w=1e-07 l=1e-07   \
 res=0.149966
XXI2\<0\>\/XI2\<7\>\/RR0 (  N_SEL0\<7\>_XI2\<0\>\/XI2\<7\>\/RR0_pos \
 N_WLSEL\<14\>_XI2\<0\>\/XI2\<7\>\/RR0_neg ) R_1X_LL w=1e-07 l=1e-07   \
 res=0.149966
XXI2\<0\>\/XI2\<6\>\/RR1 (  N_SEL1\<0\>_XI2\<0\>\/XI2\<6\>\/RR1_pos \
 N_WLSEL\<13\>_XI2\<0\>\/XI2\<6\>\/RR1_neg ) R_1X_LL w=1e-07 l=1e-07   \
 res=0.149966
XXI2\<0\>\/XI2\<6\>\/RR0 (  N_SEL0\<6\>_XI2\<0\>\/XI2\<6\>\/RR0_pos \
 N_WLSEL\<12\>_XI2\<0\>\/XI2\<6\>\/RR0_neg ) R_1X_LL w=1e-07 l=1e-07   \
 res=0.149966
XXI2\<0\>\/XI2\<5\>\/RR1 (  N_SEL1\<0\>_XI2\<0\>\/XI2\<5\>\/RR1_pos \
 N_WLSEL\<11\>_XI2\<0\>\/XI2\<5\>\/RR1_neg ) R_1X_LL w=1e-07 l=1e-07   \
 res=0.149966
XXI2\<0\>\/XI2\<5\>\/RR0 (  N_SEL0\<5\>_XI2\<0\>\/XI2\<5\>\/RR0_pos \
 N_WLSEL\<10\>_XI2\<0\>\/XI2\<5\>\/RR0_neg ) R_1X_LL w=1e-07 l=1e-07   \
 res=0.149966
XXI2\<0\>\/XI2\<4\>\/RR1 (  N_SEL1\<0\>_XI2\<0\>\/XI2\<4\>\/RR1_pos \
 N_WLSEL\<9\>_XI2\<0\>\/XI2\<4\>\/RR1_neg ) R_1X_LL w=1e-07 l=1e-07   \
 res=0.149966
XXI2\<0\>\/XI2\<4\>\/RR0 (  N_SEL0\<4\>_XI2\<0\>\/XI2\<4\>\/RR0_pos \
 N_WLSEL\<8\>_XI2\<0\>\/XI2\<4\>\/RR0_neg ) R_1X_LL w=1e-07 l=1e-07   \
 res=0.149966
XXI2\<0\>\/XI2\<3\>\/RR1 (  N_SEL1\<0\>_XI2\<0\>\/XI2\<3\>\/RR1_pos \
 N_WLSEL\<7\>_XI2\<0\>\/XI2\<3\>\/RR1_neg ) R_1X_LL w=1e-07 l=1e-07   \
 res=0.149966
XXI2\<0\>\/XI2\<3\>\/RR0 (  N_SEL0\<3\>_XI2\<0\>\/XI2\<3\>\/RR0_pos \
 N_WLSEL\<6\>_XI2\<0\>\/XI2\<3\>\/RR0_neg ) R_1X_LL w=1e-07 l=1e-07   \
 res=0.149966
XXI2\<0\>\/XI2\<2\>\/RR1 (  N_SEL1\<0\>_XI2\<0\>\/XI2\<2\>\/RR1_pos \
 N_WLSEL\<5\>_XI2\<0\>\/XI2\<2\>\/RR1_neg ) R_1X_LL w=1e-07 l=1e-07   \
 res=0.149966
XXI2\<0\>\/XI2\<2\>\/RR0 (  N_SEL0\<2\>_XI2\<0\>\/XI2\<2\>\/RR0_pos \
 N_WLSEL\<4\>_XI2\<0\>\/XI2\<2\>\/RR0_neg ) R_1X_LL w=1e-07 l=1e-07   \
 res=0.149966
XXI2\<0\>\/XI2\<1\>\/RR1 (  N_SEL1\<0\>_XI2\<0\>\/XI2\<1\>\/RR1_pos \
 N_WLSEL\<3\>_XI2\<0\>\/XI2\<1\>\/RR1_neg ) R_1X_LL w=1e-07 l=1e-07   \
 res=0.149966
XXI2\<0\>\/XI2\<1\>\/RR0 (  N_SEL0\<1\>_XI2\<0\>\/XI2\<1\>\/RR0_pos \
 N_WLSEL\<2\>_XI2\<0\>\/XI2\<1\>\/RR0_neg ) R_1X_LL w=1e-07 l=1e-07   \
 res=0.149966
XXI2\<0\>\/XI2\<0\>\/RR1 (  N_SEL1\<0\>_XI2\<0\>\/XI2\<0\>\/RR1_pos \
 N_WLSEL\<1\>_XI2\<0\>\/XI2\<0\>\/RR1_neg ) R_1X_LL w=1e-07 l=1e-07   \
 res=0.149966
XXI2\<0\>\/XI2\<0\>\/RR0 (  N_SEL0\<0\>_XI2\<0\>\/XI2\<0\>\/RR0_pos \
 N_WLSEL\<0\>_XI2\<0\>\/XI2\<0\>\/RR0_neg ) R_1X_LL w=1e-07 l=1e-07   \
 res=0.149966
//
include "/home/edauser60/2022_project/CDS_VISIO/project_pex/Post_L2_256t2_Text/spectreText/spectre.scs.POST_L2_256T2_EX.pxi"
//
ends POST_L2_256T2_TEXT
//
//
